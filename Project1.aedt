# Ansys Electronics Desktop project, version 2021.2
materials:
  vacuum: permittivity=1

design Maxwell2DDesign1 (Maxwell 2D, Magnetostatic, XY geometry, model units mm)
variables:
  Di = 5484.975692mm  # Stator Inner Diameter
  Do = 6094.417435mm  # Stator Outer Diameter
  d_o = 5454.808326mm  # Rotor Outer Diameter
  d_sh = 4000mm  # Shaft Diameter
  airgap = 15.08368315mm
  L = 1076.972459mm  # Effective Axial Length
  slot_h = 102.077952mm  # Slot Height
  slot_w = 22.63265393mm  # Slot Width
  tooth_w = 45.74654979mm  # Tooth Width
geometry:
  SalientPoleCore1 [vacuum] = user_primitive(RMxprt/SalientPoleCore.dll, DiaGap=5454.8083mm, DiaYoke=4000mm, Length=0mm, Skew=0deg, Slots=0, SlotType=1, Hs0=0.5mm, Hs01=0mm, Hs1=0mm, Hs2=0mm, Bs0=1mm, Bs1=5mm, Bs2=5mm, Rs=0mm, FilletType=0, SlotPitch=10deg, CenterPitch=12deg, Poles=32, PoleType=1, WidthShoe=(360.2540796+80) mm, HeightShoe=98.782037mm, WidthBody=360.25408mm, HeightBody=358.43157mm, AirGap2=0mm, Offset=5mm, Off2_x=0mm, Off2_y=0mm, Bp1/Rp1=0mm, Bp2/Rp2=0mm, CoilEndExt=2mm, EndRingType=2, BarEndExt=2mm, RingLength=5mm, RingHeight=6mm, SegAngle=15deg, LenRegion=200mm, InfoCore=0)
  SlotCore1 [vacuum] = user_primitive(RMxprt/SlotCore.dll, DiaGap=Di, DiaYoke=Do, Length=0mm, Skew=0deg, Slots=252, SlotType=6, Hs0=1mm, Hs01=0mm, Hs1=1mm, Hs2=slot_h, Bs0=slot_w, Bs1=0mm, Bs2=slot_w, Rs=0mm, FilletType=0, HalfSlot=0, SegAngle=15deg, LenRegion=200mm, InfoCore=0)
  LapCoil1 [vacuum] = user_primitive(RMxprt/LapCoil.dll, DiaGap=Di, DiaYoke=Do, Length=0mm, Skew=0deg, Slots=252, SlotType=6, Hs0=1mm, Hs1=1mm, Hs2=slot_h, Bs0=slot_w, Bs1=2mm, Bs2=slot_w, Rs=0mm, FilletType=0, Layers=2, CoilPitch=8, EndExt=5mm, SpanExt=25mm, BendAngle=0deg, SegAngle=10deg, LenRegion=200mm, InfoCoil=0)
  SalientPoleCore2 [vacuum] = user_primitive(RMxprt/SalientPoleCore.dll, DiaGap=5454.8083mm, DiaYoke=4000mm, Length=0mm, Skew=0deg, Slots=0, SlotType=1, Hs0=0.5mm, Hs01=0mm, Hs1=0mm, Hs2=0mm, Bs0=1mm, Bs1=5mm, Bs2=5mm, Rs=0mm, FilletType=0, SlotPitch=10deg, CenterPitch=12deg, Poles=32, PoleType=1, WidthShoe=(360.2540796+80) mm, HeightShoe=98.782037mm, WidthBody=360.25408mm, HeightBody=300mm, AirGap2=0mm, Offset=5mm, Off2_x=0mm, Off2_y=0mm, Bp1/Rp1=0mm, Bp2/Rp2=0mm, CoilEndExt=2mm, EndRingType=2, BarEndExt=2mm, RingLength=5mm, RingHeight=6mm, SegAngle=15deg, LenRegion=200mm, InfoCore=2)
mesh:
  initial mesh: MeshMethod=AnsoftTAU
