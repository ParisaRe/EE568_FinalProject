# Ansys Electronics Desktop project, version 2021.2
materials:
  vacuum: permittivity=1
  copper: permeability=0.999991 conductivity=58000000
  Cogent Power - M270-50A, 50Hz: core_loss_curve{50Hz (0, 0) (0.05, 0.01) (0.1, 0.02) (0.15, 0.045) (0.2, 0.07) (0.25, 0.105) (0.3, 0.14) (0.35, 0.185) (0.4, 0.23) (0.45, 0.28) (0.5, 0.33) (0.55, 0.39) (0.6, 0.45) (0.65, 0.515) (0.7, 0.58) (0.75, 0.655) (0.8, 0.73) (0.85, 0.815) (0.9, 0.9) (0.95, 0.985) (1, 1.07) (1.05, 1.17) (1.1, 1.27) (1.15, 1.385) (1.2, 1.5) (1.25, 1.63) (1.3, 1.76) (1.35, 1.945) (1.4, 2.13) (1.45, 2.325) (1.5, 2.52) (1.55, 2.695) (1.6, 2.87) (1.65, 3) (1.7, 3.13) (1.75, 3.25) (1.8, 3.37)} core_loss_curve{100Hz (0, 0) (0.05, 0.02) (0.1, 0.04) (0.15, 0.105) (0.2, 0.17) (0.25, 0.26) (0.3, 0.35) (0.35, 0.465) (0.4, 0.58) (0.45, 0.715) (0.5, 0.85) (0.55, 1.005) (0.6, 1.16) (0.65, 1.335) (0.7, 1.51) (0.75, 1.705) (0.8, 1.9) (0.85, 2.115) (0.9, 2.33) (0.95, 2.57) (1, 2.81) (1.05, 3.085) (1.1, 3.36) (1.15, 3.67) (1.2, 3.98) (1.25, 4.345) (1.3, 4.71) (1.35, 5.165) (1.4, 5.62) (1.45, 6.155) (1.5, 6.69) (1.55, 7.225) (1.6, 7.76) (1.65, 8.295) (1.7, 8.83) (1.75, 9.365) (1.8, 9.9)} core_loss_curve{200Hz (0, 0) (0.05, 0.05) (0.1, 0.1) (0.15, 0.265) (0.2, 0.43) (0.25, 0.67) (0.3, 0.91) (0.35, 1.21) (0.4, 1.51) (0.45, 1.875) (0.5, 2.24) (0.55, 2.665) (0.6, 3.09) (0.65, 3.58) (0.7, 4.07) (0.75, 4.63) (0.8, 5.19) (0.85, 5.83) (0.9, 6.47) (0.95, 7.205) (1, 7.94) (1.05, 8.775) (1.1, 9.61) (1.15, 10.555) (1.2, 11.5) (1.25, 12.55) (1.3, 13.6) (1.35, 14.95) (1.4, 16.3) (1.45, 17.75) (1.5, 19.2) (1.55, 20.65) (1.6, 22.1) (1.65, 23.55) (1.7, 25) (1.75, 26.45) (1.8, 27.9)} core_loss_curve{400Hz (0, 0) (0.05, 0.145) (0.1, 0.29) (0.15, 0.72) (0.2, 1.15) (0.25, 1.815) (0.3, 2.48) (0.35, 3.325) (0.4, 4.17) (0.45, 5.205) (0.5, 6.24) (0.55, 7.495) (0.6, 8.75) (0.65, 10.225) (0.7, 11.7) (0.75, 13.45) (0.8, 15.2) (0.85, 17.25) (0.9, 19.3) (0.95, 21.7) (1, 24.1) (1.05, 26.9) (1.1, 29.7) (1.15, 32.85) (1.2, 36) (1.25, 39.65) (1.3, 43.3) (1.35, 47.6) (1.4, 51.9) (1.45, 56.9) (1.5, 61.9) (1.55, 66.9) (1.6, 71.9) (1.65, 76.9) (1.7, 81.9) (1.75, 86.9) (1.8, 91.9)} core_loss_curve{1000Hz (0, 0) (0.05, 0.7) (0.1, 1.4) (0.15, 3.205) (0.2, 5.01) (0.25, 7.605) (0.3, 10.2) (0.35, 13.7) (0.4, 17.2) (0.45, 21.65) (0.5, 26.1) (0.55, 31.75) (0.6, 37.4) (0.65, 44.4) (0.7, 51.4) (0.75, 60.05) (0.8, 68.7) (0.85, 79.15) (0.9, 89.6) (0.95, 102.3) (1, 115) (1.05, 130) (1.1, 145) (1.15, 160) (1.2, 175) (1.25, 190) (1.3, 205) (1.35, 220) (1.4, 235) (1.45, 250) (1.5, 265) (1.55, 280) (1.6, 295) (1.65, 310) (1.7, 325) (1.75, 340) (1.8, 355)} permeability{HUnit=A_per_meter BUnit=tesla curve (0, 0) (5, 0.00848205) (10, 0.0186535) (20, 0.0452376) (31.5, 0.1) (42, 0.2) (49.4, 0.3) (56.1, 0.4) (63.1, 0.5) (70.7, 0.6) (79.5, 0.7) (90.1, 0.8) (103, 0.9) (121, 1) (145, 1.1) (185, 1.2) (273, 1.3) (557, 1.4) (1520, 1.5) (3560, 1.6) (6730, 1.7) (11400, 1.8) (20000, 1.89285) (40000, 2.0116) (75000, 2.11928) (130000, 2.21351) (236790, 2.3745) (431300, 2.6336) (785590, 3.0869) (1430900, 3.9022)} conductivity=1818180 core_loss_type="Electrical Steel" core_loss_kh=216.205 core_loss_kc=0.595593 core_loss_ke=2.66671 mass_density=7650

design Maxwell2DDesign5 (Maxwell 2D, Transient, XY geometry, model units mm)
options: ComputeTransientInductance ModelDepth=L
variables:
  Di = 5484.975692mm  # Stator Inner Diameter
  Do = 6094.417435mm  # Stator Outer Diameter
  d_o = 5454.808326mm  # Rotor Outer Diameter
  d_sh = 4000mm  # Shaft Diameter
  airgap = 15.08368315mm
  L = 1076.972459mm  # Effective Axial Length
  slot_h = 102.077952mm  # Slot Height
  slot_w = 22.63265393mm  # Slot Width
  tooth_w = 45.74654979mm  # Tooth Width
  Ra = 0.0087ohm
  La = 0.0002H
  delta = -acos(0.9)
  cond = 1
  InitialPosition = (360/252*45/2)+(2.5*360/252) deg
  pos_int = 40deg
geometry:
  Rotor [Cogent Power - M270-50A, 50Hz] = user_primitive(RMxprt/SalientPoleCore.dll, DiaGap=5454.8083mm, DiaYoke=4000mm, Length=0mm, Skew=0deg, Slots=0, SlotType=1, Hs0=0.5mm, Hs01=0mm, Hs1=0mm, Hs2=0mm, Bs0=1mm, Bs1=5mm, Bs2=5mm, Rs=0mm, FilletType=0, SlotPitch=10deg, CenterPitch=12deg, Poles=32, PoleType=1, WidthShoe=(360.2540796+80) mm, HeightShoe=98.782037mm, WidthBody=360.25408mm, HeightBody=358.43157mm, AirGap2=0mm, Offset=5mm, Off2_x=0mm, Off2_y=0mm, Bp1/Rp1=0mm, Bp2/Rp2=0mm, CoilEndExt=2mm, EndRingType=2, BarEndExt=2mm, RingLength=5mm, RingHeight=6mm, SegAngle=15deg, LenRegion=0mm, InfoCore=7)
  Stator [Cogent Power - M270-50A, 50Hz] = user_primitive(RMxprt/SlotCore.dll, DiaGap=Di, DiaYoke=Do, Length=0mm, Skew=0deg, Slots=252, SlotType=6, Hs0=1mm, Hs01=0mm, Hs1=1mm, Hs2=slot_h, Bs0=slot_w, Bs1=0mm, Bs2=slot_w, Rs=0mm, FilletType=0, HalfSlot=0, SegAngle=15deg, LenRegion=0mm, InfoCore=0)
  PhaseB6 [copper] = user_primitive(RMxprt/LapCoil.dll, DiaGap=Di, DiaYoke=Do, Length=0mm, Skew=0deg, Slots=252, SlotType=6, Hs0=1mm, Hs1=1mm, Hs2=slot_h, Bs0=slot_w, Bs1=2mm, Bs2=slot_w, Rs=0mm, FilletType=0, Layers=2, CoilPitch=8, EndExt=5mm, SpanExt=25mm, BendAngle=0deg, SegAngle=10deg, LenRegion=0mm, InfoCoil=0)
  Field1 [copper] = user_primitive(RMxprt/SalientPoleCore.dll, DiaGap=5454.8083mm, DiaYoke=4000mm, Length=0mm, Skew=0deg, Slots=0, SlotType=1, Hs0=0.5mm, Hs01=0mm, Hs1=0mm, Hs2=0mm, Bs0=1mm, Bs1=5mm, Bs2=5mm, Rs=0mm, FilletType=0, SlotPitch=10deg, CenterPitch=12deg, Poles=32, PoleType=1, WidthShoe=(360.2540796+80) mm, HeightShoe=98.782037mm, WidthBody=360.25408mm, HeightBody=300mm, AirGap2=0mm, Offset=0mm, Off2_x=0mm, Off2_y=0mm, Bp1/Rp1=0mm, Bp2/Rp2=0mm, CoilEndExt=0.1mm, EndRingType=0, BarEndExt=0mm, RingLength=0mm, RingHeight=0mm, SegAngle=15deg, LenRegion=0mm, InfoCore=4)
  Poles [Cogent Power - M270-50A, 50Hz] = user_primitive(RMxprt/SalientPoleCore.dll, DiaGap=5454.8083mm, DiaYoke=4000mm, Length=0mm, Skew=0deg, Slots=0, SlotType=1, Hs0=0.5mm, Hs01=0mm, Hs1=0mm, Hs2=0mm, Bs0=1mm, Bs1=5mm, Bs2=5mm, Rs=0mm, FilletType=0, SlotPitch=10deg, CenterPitch=12deg, Poles=32, PoleType=1, WidthShoe=(360.2540796+80) mm, HeightShoe=98.782037mm, WidthBody=360.25408mm, HeightBody=358.43157mm, AirGap2=0mm, Offset=5mm, Off2_x=0mm, Off2_y=0mm, Bp1/Rp1=0mm, Bp2/Rp2=0mm, CoilEndExt=2mm, EndRingType=2, BarEndExt=2mm, RingLength=5mm, RingHeight=6mm, SegAngle=15deg, LenRegion=0mm, InfoCore=6)
  Field2 [copper] = user_primitive(RMxprt/SalientPoleCore.dll, DiaGap=5454.8083mm, DiaYoke=4000mm, Length=0mm, Skew=0deg, Slots=0, SlotType=1, Hs0=0.5mm, Hs01=0mm, Hs1=0mm, Hs2=0mm, Bs0=1mm, Bs1=5mm, Bs2=5mm, Rs=0mm, FilletType=0, SlotPitch=10deg, CenterPitch=12deg, Poles=32, PoleType=1, WidthShoe=(360.2540796+80) mm, HeightShoe=98.782037mm, WidthBody=360.25408mm, HeightBody=300mm, AirGap2=0mm, Offset=0mm, Off2_x=0mm, Off2_y=0mm, Bp1/Rp1=0mm, Bp2/Rp2=0mm, CoilEndExt=0.1mm, EndRingType=0, BarEndExt=0mm, RingLength=0mm, RingHeight=0mm, SegAngle=15deg, LenRegion=0mm, InfoCore=5)
  Shaft [vacuum] = circle(normal=Z, centre=(0mm, 0mm, 0mm), radius=2000mm)
  [Stator, Shaft, Rotor, Poles, PhaseB6].split(plane=YZ, keep=PositiveOnly)
  [Stator, Shaft, Rotor, Poles, PhaseB6].split(plane=ZX, keep=PositiveOnly)
  Field3, Field5, Field7, Field9, Field11, Field13, Field15 [copper] = Field1.duplicate_around_axis(axis=Z, angle=(360/32) deg, total=9)  # copies kept: 1..7
  Field4, Field6, Field8, Field10, Field12, Field14, Field16 [copper] = Field2.duplicate_around_axis(axis=Z, angle=(360/32) deg, total=9)  # copies kept: 1..7
  PhaseB2, PhaseC2, PhaseA4, PhaseB39, PhaseC39, PhaseA37, PhaseA39, PhaseB34, PhaseB40, PhaseC33, PhaseC40, PhaseA33, PhaseA38, PhaseA43, PhaseA45, PhaseB30, PhaseB35, PhaseC27, PhaseC34, PhaseA28, PhaseA34, PhaseA42, PhaseA44, PhaseB25, PhaseB31, PhaseC22, PhaseC28, PhaseA22, PhaseA29, PhaseB23, PhaseB29, PhaseB19, PhaseB26, PhaseC18, PhaseC23, PhaseA18, PhaseA23, PhaseB17, PhaseB24, PhaseB13, PhaseB20, PhaseC12, PhaseC19, PhaseA14, PhaseA19, PhaseB11, PhaseB18, PhaseB7, PhaseB14, PhaseC6, PhaseC13, PhaseA9, PhaseA15, PhaseB5, PhaseB12, PhaseB1, PhaseB8, PhaseC1, PhaseC7, PhaseA10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 [copper] = PhaseB6.separate_bodies()
  Band_out [vacuum] = polyline((0mm, 0mm, 0mm) (Di/2-airgap/4, 0mm, 0mm))
  Band_out.sweep_around_axis(axis=Z, angle=90deg, segments=126)
  Band_in [vacuum] = polyline((0mm, 0mm, 0mm) (Di/2-airgap*3/4, 0mm, 0mm))
  Band_in.sweep_around_axis(axis=Z, angle=90deg, segments=126)
  Band [vacuum] = polyline((0mm, 0mm, 0mm) (Di/2-airgap/2, 0mm, 0mm))
  Band.sweep_around_axis(axis=Z, angle=90deg, segments=126)
  Region [vacuum] = polyline((0mm, 0mm, 0mm) (Di/2+500mm, 0mm, 0mm))
  Region.sweep_around_axis(axis=Z, angle=90deg, segments=5)
motion:
  MotionSetup1: Band Move_Type=Rotate Coordinate_System=Global Axis=Z Is_Positive=true InitPos=InitialPosition Angular_Velocity=187.5rpm Objects=Band
  Moving1: Moving Objects=[Rotor, Field1, Poles, Field2, Shaft, Field3, Field5, Field7, Field9, Field11, Field13, Field15, Field4, Field6, Field8, Field10, Field12, Field14, Field16, Band_in]
boundaries and excitations:
  VectorPotential1: Vector Potential Edges=Region.edge(#71553, #71554, #71555, #71556, #71557, #71558) Value=0
  Independent1: Independent Edges=Region.edge(1 of 1)
  Dependent1: Dependent Edges=Region.edge(#71559) ReverseU Independent=Independent1 SameAsMaster=true
  Field1: Coil Objects=Field1 Conductor_number=5 Winding=Field PolarityType=Positive
  Field2: Coil Objects=Field2 Conductor_number=5 Winding=Field PolarityType=Negative
  Field3: Coil Objects=Field3 Conductor_number=5 Winding=Field PolarityType=Negative
  Field4: Coil Objects=Field4 Conductor_number=5 Winding=Field PolarityType=Positive
  Field5: Coil Objects=Field5 Conductor_number=5 Winding=Field PolarityType=Positive
  Field6: Coil Objects=Field6 Conductor_number=5 Winding=Field PolarityType=Negative
  Field7: Coil Objects=Field7 Conductor_number=5 Winding=Field PolarityType=Negative
  Field8: Coil Objects=Field8 Conductor_number=5 Winding=Field PolarityType=Positive
  Field9: Coil Objects=Field9 Conductor_number=5 Winding=Field PolarityType=Positive
  Field10: Coil Objects=Field10 Conductor_number=5 Winding=Field PolarityType=Negative
  Field11: Coil Objects=Field11 Conductor_number=5 Winding=Field PolarityType=Negative
  Field12: Coil Objects=Field12 Conductor_number=5 Winding=Field PolarityType=Positive
  Field13: Coil Objects=Field13 Conductor_number=5 Winding=Field PolarityType=Positive
  Field14: Coil Objects=Field14 Conductor_number=5 Winding=Field PolarityType=Negative
  Field15: Coil Objects=Field15 Conductor_number=5 Winding=Field PolarityType=Negative
  Field16: Coil Objects=Field16 Conductor_number=5 Winding=Field PolarityType=Positive
  PhaseA1: Coil Objects=PhaseA1 Conductor_number=cond Winding=PhaseA PolarityType=Positive
  PhaseA2: Coil Objects=PhaseA2 Conductor_number=cond Winding=PhaseA PolarityType=Positive
  PhaseA3: Coil Objects=PhaseA3 Conductor_number=cond Winding=PhaseA PolarityType=Positive
  PhaseA4: Coil Objects=PhaseA4 Conductor_number=cond Winding=PhaseA PolarityType=Positive
  PhaseA5: Coil Objects=PhaseA5 Conductor_number=cond Winding=PhaseA PolarityType=Positive
  PhaseA6: Coil Objects=PhaseA6 Conductor_number=cond Winding=PhaseA PolarityType=Positive
  PhaseA7: Coil Objects=PhaseA7 Conductor_number=cond Winding=PhaseA PolarityType=Negative
  PhaseA8: Coil Objects=PhaseA8 Conductor_number=cond Winding=PhaseA PolarityType=Negative
  PhaseA9: Coil Objects=PhaseA9 Conductor_number=cond Winding=PhaseA PolarityType=Negative
  PhaseA10: Coil Objects=PhaseA10 Conductor_number=cond Winding=PhaseA PolarityType=Negative
  PhaseA11: Coil Objects=PhaseA11 Conductor_number=cond Winding=PhaseA PolarityType=Negative
  PhaseA12: Coil Objects=PhaseA12 Conductor_number=cond Winding=PhaseA PolarityType=Positive
  PhaseA13: Coil Objects=PhaseA13 Conductor_number=cond Winding=PhaseA PolarityType=Positive
  PhaseA14: Coil Objects=PhaseA14 Conductor_number=cond Winding=PhaseA PolarityType=Positive
  PhaseA15: Coil Objects=PhaseA15 Conductor_number=cond Winding=PhaseA PolarityType=Positive
  PhaseA16: Coil Objects=PhaseA16 Conductor_number=cond Winding=PhaseA PolarityType=Negative
  PhaseA17: Coil Objects=PhaseA17 Conductor_number=cond Winding=PhaseA PolarityType=Negative
  PhaseA18: Coil Objects=PhaseA18 Conductor_number=cond Winding=PhaseA PolarityType=Negative
  PhaseA19: Coil Objects=PhaseA19 Conductor_number=cond Winding=PhaseA PolarityType=Negative
  PhaseA20: Coil Objects=PhaseA20 Conductor_number=cond Winding=PhaseA PolarityType=Positive
  PhaseA21: Coil Objects=PhaseA21 Conductor_number=cond Winding=PhaseA PolarityType=Positive
  PhaseA22: Coil Objects=PhaseA22 Conductor_number=cond Winding=PhaseA PolarityType=Positive
  PhaseA23: Coil Objects=PhaseA23 Conductor_number=cond Winding=PhaseA PolarityType=Positive
  PhaseA26: Coil Objects=PhaseA26 Conductor_number=cond Winding=PhaseA PolarityType=Negative
  PhaseA27: Coil Objects=PhaseA27 Conductor_number=cond Winding=PhaseA PolarityType=Negative
  PhaseA28: Coil Objects=PhaseA28 Conductor_number=cond Winding=PhaseA PolarityType=Negative
  PhaseA29: Coil Objects=PhaseA29 Conductor_number=cond Winding=PhaseA PolarityType=Negative
  PhaseA31: Coil Objects=PhaseA31 Conductor_number=cond Winding=PhaseA PolarityType=Positive
  PhaseA32: Coil Objects=PhaseA32 Conductor_number=cond Winding=PhaseA PolarityType=Positive
  PhaseA33: Coil Objects=PhaseA33 Conductor_number=cond Winding=PhaseA PolarityType=Positive
  PhaseA34: Coil Objects=PhaseA34 Conductor_number=cond Winding=PhaseA PolarityType=Positive
  PhaseA35: Coil Objects=PhaseA35 Conductor_number=cond Winding=PhaseA PolarityType=Negative
  PhaseA36: Coil Objects=PhaseA36 Conductor_number=cond Winding=PhaseA PolarityType=Negative
  PhaseA37: Coil Objects=PhaseA37 Conductor_number=cond Winding=PhaseA PolarityType=Negative
  PhaseA38: Coil Objects=PhaseA38 Conductor_number=cond Winding=PhaseA PolarityType=Negative
  PhaseA39: Coil Objects=PhaseA39 Conductor_number=cond Winding=PhaseA PolarityType=Negative
  PhaseA40: Coil Objects=PhaseA40 Conductor_number=cond Winding=PhaseA PolarityType=Negative
  PhaseA41: Coil Objects=PhaseA41 Conductor_number=cond Winding=PhaseA PolarityType=Positive
  PhaseA42: Coil Objects=PhaseA42 Conductor_number=cond Winding=PhaseA PolarityType=Negative
  PhaseA43: Coil Objects=PhaseA43 Conductor_number=cond Winding=PhaseA PolarityType=Positive
  PhaseA44: Coil Objects=PhaseA44 Conductor_number=cond Winding=PhaseA PolarityType=Positive
  PhaseA45: Coil Objects=PhaseA45 Conductor_number=cond Winding=PhaseA PolarityType=Negative
  PhaseB1: Coil Objects=PhaseB1 Conductor_number=cond Winding=PhaseB PolarityType=Positive
  PhaseB2: Coil Objects=PhaseB2 Conductor_number=cond Winding=PhaseB PolarityType=Positive
  PhaseB3: Coil Objects=PhaseB3 Conductor_number=cond Winding=PhaseB PolarityType=Positive
  PhaseB4: Coil Objects=PhaseB4 Conductor_number=cond Winding=PhaseB PolarityType=Positive
  PhaseB5: Coil Objects=PhaseB5 Conductor_number=cond Winding=PhaseB PolarityType=Positive
  PhaseB6: Coil Objects=PhaseB6 Conductor_number=cond Winding=PhaseB PolarityType=Positive
  PhaseB7: Coil Objects=PhaseB7 Conductor_number=cond Winding=PhaseB PolarityType=Negative
  PhaseB8: Coil Objects=PhaseB8 Conductor_number=cond Winding=PhaseB PolarityType=Negative
  PhaseB9: Coil Objects=PhaseB9 Conductor_number=cond Winding=PhaseB PolarityType=Negative
  PhaseB10: Coil Objects=PhaseB10 Conductor_number=cond Winding=PhaseB PolarityType=Negative
  PhaseB11: Coil Objects=PhaseB11 Conductor_number=cond Winding=PhaseB PolarityType=Negative
  PhaseB12: Coil Objects=PhaseB12 Conductor_number=cond Winding=PhaseB PolarityType=Negative
  PhaseB13: Coil Objects=PhaseB13 Conductor_number=cond Winding=PhaseB PolarityType=Positive
  PhaseB14: Coil Objects=PhaseB14 Conductor_number=cond Winding=PhaseB PolarityType=Positive
  PhaseB15: Coil Objects=PhaseB15 Conductor_number=cond Winding=PhaseB PolarityType=Positive
  PhaseB16: Coil Objects=PhaseB16 Conductor_number=cond Winding=PhaseB PolarityType=Positive
  PhaseB17: Coil Objects=PhaseB17 Conductor_number=cond Winding=PhaseB PolarityType=Positive
  PhaseB18: Coil Objects=PhaseB18 Conductor_number=cond Winding=PhaseB PolarityType=Positive
  PhaseB19: Coil Objects=PhaseB19 Conductor_number=cond Winding=PhaseB PolarityType=Negative
  PhaseB20: Coil Objects=PhaseB20 Conductor_number=cond Winding=PhaseB PolarityType=Negative
  PhaseB21: Coil Objects=PhaseB21 Conductor_number=cond Winding=PhaseB PolarityType=Negative
  PhaseB22: Coil Objects=PhaseB22 Conductor_number=cond Winding=PhaseB PolarityType=Negative
  PhaseB23: Coil Objects=PhaseB23 Conductor_number=cond Winding=PhaseB PolarityType=Negative
  PhaseB24: Coil Objects=PhaseB24 Conductor_number=cond Winding=PhaseB PolarityType=Negative
  PhaseB25: Coil Objects=PhaseB25 Conductor_number=cond Winding=PhaseB PolarityType=Positive
  PhaseB26: Coil Objects=PhaseB26 Conductor_number=cond Winding=PhaseB PolarityType=Positive
  PhaseB27: Coil Objects=PhaseB27 Conductor_number=cond Winding=PhaseB PolarityType=Positive
  PhaseB28: Coil Objects=PhaseB28 Conductor_number=cond Winding=PhaseB PolarityType=Positive
  PhaseB29: Coil Objects=PhaseB29 Conductor_number=cond Winding=PhaseB PolarityType=Positive
  PhaseB30: Coil Objects=PhaseB30 Conductor_number=cond Winding=PhaseB PolarityType=Negative
  PhaseB31: Coil Objects=PhaseB31 Conductor_number=cond Winding=PhaseB PolarityType=Negative
  PhaseB32: Coil Objects=PhaseB32 Conductor_number=cond Winding=PhaseB PolarityType=Negative
  PhaseB33: Coil Objects=PhaseB33 Conductor_number=cond Winding=PhaseB PolarityType=Negative
  PhaseB34: Coil Objects=PhaseB34 Conductor_number=cond Winding=PhaseB PolarityType=Positive
  PhaseB35: Coil Objects=PhaseB35 Conductor_number=cond Winding=PhaseB PolarityType=Positive
  PhaseB36: Coil Objects=PhaseB36 Conductor_number=cond Winding=PhaseB PolarityType=Positive
  PhaseB37: Coil Objects=PhaseB37 Conductor_number=cond Winding=PhaseB PolarityType=Positive
  PhaseB38: Coil Objects=PhaseB38 Conductor_number=cond Winding=PhaseB PolarityType=Negative
  PhaseB39: Coil Objects=PhaseB39 Conductor_number=cond Winding=PhaseB PolarityType=Negative
  PhaseB40: Coil Objects=PhaseB40 Conductor_number=cond Winding=PhaseB PolarityType=Negative
  PhaseB41: Coil Objects=PhaseB41 Conductor_number=cond Winding=PhaseB PolarityType=Negative
  PhaseB42: Coil Objects=PhaseB42 Conductor_number=cond Winding=PhaseB PolarityType=Negative
  PhaseC1: Coil Objects=PhaseC1 Conductor_number=cond Winding=PhaseC PolarityType=Negative
  PhaseC2: Coil Objects=PhaseC2 Conductor_number=cond Winding=PhaseC PolarityType=Negative
  PhaseC3: Coil Objects=PhaseC3 Conductor_number=cond Winding=PhaseC PolarityType=Negative
  PhaseC4: Coil Objects=PhaseC4 Conductor_number=cond Winding=PhaseC PolarityType=Negative
  PhaseC6: Coil Objects=PhaseC6 Conductor_number=cond Winding=PhaseC PolarityType=Positive
  PhaseC7: Coil Objects=PhaseC7 Conductor_number=cond Winding=PhaseC PolarityType=Positive
  PhaseC8: Coil Objects=PhaseC8 Conductor_number=cond Winding=PhaseC PolarityType=Positive
  PhaseC9: Coil Objects=PhaseC9 Conductor_number=cond Winding=PhaseC PolarityType=Positive
  PhaseC10: Coil Objects=PhaseC10 Conductor_number=cond Winding=PhaseC PolarityType=Negative
  PhaseC12: Coil Objects=PhaseC12 Conductor_number=cond Winding=PhaseC PolarityType=Negative
  PhaseC13: Coil Objects=PhaseC13 Conductor_number=cond Winding=PhaseC PolarityType=Negative
  PhaseC14: Coil Objects=PhaseC14 Conductor_number=cond Winding=PhaseC PolarityType=Negative
  PhaseC15: Coil Objects=PhaseC15 Conductor_number=cond Winding=PhaseC PolarityType=Negative
  PhaseC16: Coil Objects=PhaseC16 Conductor_number=cond Winding=PhaseC PolarityType=Positive
  PhaseC17: Coil Objects=PhaseC17 Conductor_number=cond Winding=PhaseC PolarityType=Positive
  PhaseC18: Coil Objects=PhaseC18 Conductor_number=cond Winding=PhaseC PolarityType=Positive
  PhaseC19: Coil Objects=PhaseC19 Conductor_number=cond Winding=PhaseC PolarityType=Positive
  PhaseC20: Coil Objects=PhaseC20 Conductor_number=cond Winding=PhaseC PolarityType=Positive
  PhaseC21: Coil Objects=PhaseC21 Conductor_number=cond Winding=PhaseC PolarityType=Positive
  PhaseC22: Coil Objects=PhaseC22 Conductor_number=cond Winding=PhaseC PolarityType=Negative
  PhaseC23: Coil Objects=PhaseC23 Conductor_number=cond Winding=PhaseC PolarityType=Negative
  PhaseC24: Coil Objects=PhaseC24 Conductor_number=cond Winding=PhaseC PolarityType=Negative
  PhaseC25: Coil Objects=PhaseC25 Conductor_number=cond Winding=PhaseC PolarityType=Negative
  PhaseC26: Coil Objects=PhaseC26 Conductor_number=cond Winding=PhaseC PolarityType=Positive
  PhaseC27: Coil Objects=PhaseC27 Conductor_number=cond Winding=PhaseC PolarityType=Positive
  PhaseC28: Coil Objects=PhaseC28 Conductor_number=cond Winding=PhaseC PolarityType=Positive
  PhaseC29: Coil Objects=PhaseC29 Conductor_number=cond Winding=PhaseC PolarityType=Positive
  PhaseC30: Coil Objects=PhaseC30 Conductor_number=cond Winding=PhaseC PolarityType=Positive
  PhaseC31: Coil Objects=PhaseC31 Conductor_number=cond Winding=PhaseC PolarityType=Negative
  PhaseC32: Coil Objects=PhaseC32 Conductor_number=cond Winding=PhaseC PolarityType=Negative
  PhaseC33: Coil Objects=PhaseC33 Conductor_number=cond Winding=PhaseC PolarityType=Negative
  PhaseC34: Coil Objects=PhaseC34 Conductor_number=cond Winding=PhaseC PolarityType=Negative
  PhaseC35: Coil Objects=PhaseC35 Conductor_number=cond Winding=PhaseC PolarityType=Negative
  PhaseC36: Coil Objects=PhaseC36 Conductor_number=cond Winding=PhaseC PolarityType=Negative
  PhaseC37: Coil Objects=PhaseC37 Conductor_number=cond Winding=PhaseC PolarityType=Positive
  PhaseC38: Coil Objects=PhaseC38 Conductor_number=cond Winding=PhaseC PolarityType=Positive
  PhaseC39: Coil Objects=PhaseC39 Conductor_number=cond Winding=PhaseC PolarityType=Positive
  PhaseC40: Coil Objects=PhaseC40 Conductor_number=cond Winding=PhaseC PolarityType=Positive
  PhaseC42: Coil Objects=PhaseC42 Conductor_number=cond Winding=PhaseC PolarityType=Positive
  PhaseC43: Coil Objects=PhaseC43 Conductor_number=cond Winding=PhaseC PolarityType=Negative
  PhaseC44: Coil Objects=PhaseC44 Conductor_number=cond Winding=PhaseC PolarityType=Negative
  PhaseC45: Coil Objects=PhaseC45 Conductor_number=cond Winding=PhaseC PolarityType=Positive
  Field: Winding Group Type=Current IsSolid=false Current=10A ParallelBranchesNum=1
  PhaseA: Winding Group Type=Voltage IsSolid=false Current=0mA Resistance=Ra Inductance=La Voltage=11267.7*sin(2*pi*50*time+delta) ParallelBranchesNum=1
  PhaseB: Winding Group Type=Voltage IsSolid=false Current=0mA Resistance=Ra Inductance=La Voltage=11267.7*sin(2*pi*50*time+delta-2*pi/3) ParallelBranchesNum=1
  PhaseC: Winding Group Type=Voltage IsSolid=false Current=0mA Resistance=Ra Inductance=La Voltage=11267.7*sin(2*pi*50*time+delta-4*pi/3) ParallelBranchesNum=1
mesh:
  initial mesh: MeshMethod=AnsoftTAU
setups:
  Setup1: Transient NonlinearSolverResidual=0.0001 StopTime=0.1s TimeStep=0.0002s FastReachSteadyState AutoDetectSteadyState FrequencyOfAddedVoltageSource=50Hz StopCriterion=0.005 InitialTimeStep=0.002s MinTimeStep=0.001s MaxTimeStep=0.003s TimeStepErrTolerance=0.0001
output variables:
  pos = (Moving1.Position -12.375 * PI/180) * 16 + PI
  cos0 = cos(pos)
  cos1 = cos(pos-2*PI/3)
  cos2 = cos(pos-4*PI/3)
  sin0 = sin(pos)
  sin1 = sin(pos-2*PI/3)
  sin2 = sin(pos-4*PI/3)
  Lad = L(PhaseA,PhaseA)*cos0 + L(PhaseA,PhaseB)*cos1 + L(PhaseA,PhaseC)*cos2
  Laq = L(PhaseA,PhaseA)*sin0 + L(PhaseA,PhaseB)*sin1 + L(PhaseA,PhaseC)*sin2
  Lbd = L(PhaseB,PhaseA)*cos0 + L(PhaseB,PhaseB)*cos1 + L(PhaseB,PhaseC)*cos2
  Lbq = L(PhaseB,PhaseA)*sin0 + L(PhaseB,PhaseB)*sin1 + L(PhaseB,PhaseC)*sin2
  Lcd = L(PhaseC,PhaseA)*cos0 + L(PhaseC,PhaseB)*cos1 + L(PhaseC,PhaseC)*cos2
  Lcq = L(PhaseC,PhaseA)*sin0 + L(PhaseC,PhaseB)*sin1 + L(PhaseC,PhaseC)*sin2
  L_d = (Lad*cos0 + Lbd*cos1 + Lcd*cos2) * 2/3
  L_q = (Laq*sin0 + Lbq*sin1 + Lcq*sin2) * 2/3
  Flux_d = (FluxLinkage(PhaseA)*cos0+FluxLinkage(PhaseB)*cos1+FluxLinkage(PhaseC)*cos2)*2/3
  Flux_q = (FluxLinkage(PhaseA)*sin0+FluxLinkage(PhaseB)*sin1+FluxLinkage(PhaseC)*sin2)*2/3
  I_d = (Current(PhaseA)*cos0 + Current(PhaseB)*cos1 + Current(PhaseC)*cos2)*2/3
  I_q = (Current(PhaseA)*sin0 + Current(PhaseB)*sin1 + Current(PhaseC)*sin2)*2/3
  Irms = sqrt(I_d^2+I_q^2)/sqrt(2)
  Pcu = 3*Irms^2*0
  ElectricPower = InputVoltage(PhaseA)*Current(PhaseA) + InputVoltage(PhaseB)*Current(PhaseB) + InputVoltage(PhaseC)*Current(PhaseC)
  MechanicalPower = Moving1.Speed*Moving1.Torque
reports:
  Torque Plot 1: Moving1.Torque vs Time on Setup1 : Transient
  Flux Linkage: FluxLinkage(PhaseA), FluxLinkage(PhaseB), FluxLinkage(PhaseC) vs Time on Setup1 : Transient
  Induced Voltage: InducedVoltage(PhaseA), InducedVoltage(PhaseB), InducedVoltage(PhaseC) vs Time on Setup1 : Transient
  Input Voltage: InputVoltage(PhaseA), InputVoltage(PhaseB), InputVoltage(PhaseC) vs Time on Setup1 : Transient
  Elec & Mech Power: ElectricPower, MechanicalPower vs Time on Setup1 : Transient
  Current: Current(PhaseA), Current(PhaseB), Current(PhaseC) vs Time on Setup1 : Transient
  dq Inductances: L_d, L_q vs Time on Setup1 : Transient
  dq Fluxes: Flux_d, Flux_q vs Time on Setup1 : Transient
  dq Currents: I_d, I_q vs Time on Setup1 : Transient
