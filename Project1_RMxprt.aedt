# Ansys Electronics Desktop project, version 2021.2
materials:
  Cogent Power - M270-50A, 50Hz: core_loss_curve{50Hz (0, 0) (0.05, 0.01) (0.1, 0.02) (0.15, 0.045) (0.2, 0.07) (0.25, 0.105) (0.3, 0.14) (0.35, 0.185) (0.4, 0.23) (0.45, 0.28) (0.5, 0.33) (0.55, 0.39) (0.6, 0.45) (0.65, 0.515) (0.7, 0.58) (0.75, 0.655) (0.8, 0.73) (0.85, 0.815) (0.9, 0.9) (0.95, 0.985) (1, 1.07) (1.05, 1.17) (1.1, 1.27) (1.15, 1.385) (1.2, 1.5) (1.25, 1.63) (1.3, 1.76) (1.35, 1.945) (1.4, 2.13) (1.45, 2.325) (1.5, 2.52) (1.55, 2.695) (1.6, 2.87) (1.65, 3) (1.7, 3.13) (1.75, 3.25) (1.8, 3.37)} core_loss_curve{100Hz (0, 0) (0.05, 0.02) (0.1, 0.04) (0.15, 0.105) (0.2, 0.17) (0.25, 0.26) (0.3, 0.35) (0.35, 0.465) (0.4, 0.58) (0.45, 0.715) (0.5, 0.85) (0.55, 1.005) (0.6, 1.16) (0.65, 1.335) (0.7, 1.51) (0.75, 1.705) (0.8, 1.9) (0.85, 2.115) (0.9, 2.33) (0.95, 2.57) (1, 2.81) (1.05, 3.085) (1.1, 3.36) (1.15, 3.67) (1.2, 3.98) (1.25, 4.345) (1.3, 4.71) (1.35, 5.165) (1.4, 5.62) (1.45, 6.155) (1.5, 6.69) (1.55, 7.225) (1.6, 7.76) (1.65, 8.295) (1.7, 8.83) (1.75, 9.365) (1.8, 9.9)} core_loss_curve{200Hz (0, 0) (0.05, 0.05) (0.1, 0.1) (0.15, 0.265) (0.2, 0.43) (0.25, 0.67) (0.3, 0.91) (0.35, 1.21) (0.4, 1.51) (0.45, 1.875) (0.5, 2.24) (0.55, 2.665) (0.6, 3.09) (0.65, 3.58) (0.7, 4.07) (0.75, 4.63) (0.8, 5.19) (0.85, 5.83) (0.9, 6.47) (0.95, 7.205) (1, 7.94) (1.05, 8.775) (1.1, 9.61) (1.15, 10.555) (1.2, 11.5) (1.25, 12.55) (1.3, 13.6) (1.35, 14.95) (1.4, 16.3) (1.45, 17.75) (1.5, 19.2) (1.55, 20.65) (1.6, 22.1) (1.65, 23.55) (1.7, 25) (1.75, 26.45) (1.8, 27.9)} core_loss_curve{400Hz (0, 0) (0.05, 0.145) (0.1, 0.29) (0.15, 0.72) (0.2, 1.15) (0.25, 1.815) (0.3, 2.48) (0.35, 3.325) (0.4, 4.17) (0.45, 5.205) (0.5, 6.24) (0.55, 7.495) (0.6, 8.75) (0.65, 10.225) (0.7, 11.7) (0.75, 13.45) (0.8, 15.2) (0.85, 17.25) (0.9, 19.3) (0.95, 21.7) (1, 24.1) (1.05, 26.9) (1.1, 29.7) (1.15, 32.85) (1.2, 36) (1.25, 39.65) (1.3, 43.3) (1.35, 47.6) (1.4, 51.9) (1.45, 56.9) (1.5, 61.9) (1.55, 66.9) (1.6, 71.9) (1.65, 76.9) (1.7, 81.9) (1.75, 86.9) (1.8, 91.9)} core_loss_curve{1000Hz (0, 0) (0.05, 0.7) (0.1, 1.4) (0.15, 3.205) (0.2, 5.01) (0.25, 7.605) (0.3, 10.2) (0.35, 13.7) (0.4, 17.2) (0.45, 21.65) (0.5, 26.1) (0.55, 31.75) (0.6, 37.4) (0.65, 44.4) (0.7, 51.4) (0.75, 60.05) (0.8, 68.7) (0.85, 79.15) (0.9, 89.6) (0.95, 102.3) (1, 115) (1.05, 130) (1.1, 145) (1.15, 160) (1.2, 175) (1.25, 190) (1.3, 205) (1.35, 220) (1.4, 235) (1.45, 250) (1.5, 265) (1.55, 280) (1.6, 295) (1.65, 310) (1.7, 325) (1.75, 340) (1.8, 355)} permeability{HUnit=A_per_meter BUnit=tesla curve (0, 0) (5, 0.00848205) (10, 0.0186535) (20, 0.0452376) (31.5, 0.1) (42, 0.2) (49.4, 0.3) (56.1, 0.4) (63.1, 0.5) (70.7, 0.6) (79.5, 0.7) (90.1, 0.8) (103, 0.9) (121, 1) (145, 1.1) (185, 1.2) (273, 1.3) (557, 1.4) (1520, 1.5) (3560, 1.6) (6730, 1.7) (11400, 1.8) (20000, 1.89285) (40000, 2.0116) (75000, 2.11928) (130000, 2.21351) (236790, 2.3745) (431300, 2.6336) (785590, 3.0869) (1430900, 3.9022)} conductivity=1818180 core_loss_type="Electrical Steel" core_loss_kh=216.205 core_loss_kc=0.595593 core_loss_ke=2.66671 mass_density=7650
  steel_1008: permeability{HUnit=A_per_meter BUnit=tesla curve (0, 0) (159.2, 0.2402) (318.3, 0.8654) (477.5, 1.1106) (636.6, 1.2458) (795.8, 1.331) (1591.5, 1.5) (3183.1, 1.6) (4774.6, 1.683) (6366.2, 1.741) (7957.7, 1.78) (15915.5, 1.905) (31831, 2.025) (47746.5, 2.085) (63662, 2.13) (79577.5, 2.165) (159155, 2.28) (318310, 2.485) (397887, 2.5851)} conductivity=2000000 mass_density=7872

design RMxprtDesign1 (RMxprt, Three Phase Synchronous Machine, model units mm)
variables:
  Di = 5484.975692mm
  Do = 6094.417435mm
  L = 1076.972459mm
  slot_h = 102.077952mm
  slot_w = 22.63265393mm
  d_o = 5454.808326mm
  d_i = 4000mm
  pole_w = 360.2540796mm
  pole_h = 358.4315657mm
  shoe_w = 450.3175995mm
  shoe_h = 98.78203737mm
machine:
  Machine: FrictionLoss=0W WindLoss=0W ReferenceSpeed=187.5rpm NumberOfPoles=32
  Stator: SkewWidth=0 NumberOfSlots=252 LaminationSectors=0 PressBoardThickness=0mm OuterDiameter=Do InnerDiameter=Di Length=L StackingFactor=0.95 SteelType="Cogent Power - M270-50A, 50Hz" SlotType=6
  Rotor: OuterDiameter=d_o InnerDiameter=d_i Length=L SteelType="Cogent Power - M270-50A, 50Hz" SecondAirGap=0mm PoleBodyHeight=pole_h PoleShoeHeight=shoe_h Off2x=0mm Off2y=0mm PoleArcOffset=0mm PoleBodyWidth=pole_w PoleShoeWidth=shoe_w PoleStackingFactor=0.97 PoleSteelType=steel_1008 PressBoardThickness=0mm StackingFactor=0.95 ShoeInsulation=0mm PoleInsulation=0mm WindingClearance=0mm
  Shaft:
  Stator Slot: Hs0=1mm Hs1=1mm Hs2=slot_h Bs0=0mm Bs1=slot_w Bs2=slot_w Rs=0mm ToothWidth=0mm
  Stator Winding: WindingType=Whole-Coiled WindingLayers=2 ParallelBranches=1 ConductorsPerSlot=2 CoilPitch=8 EndAdjustment=0mm BaseInnerRadius=0mm TipInnerDiameter=0mm EndClearance=0mm CoilWrap=0mm SlotLiner=0mm WedgeThickness=0mm LayerInsulation=0mm BottomInsulation=0mm LimitedFillFactor=0.75 WdgNumberofPriodicMultipler=1 NumberOfStrands=40 WireWrap=0mm InterturnInsulation=0mm WireDiameter=0mm WireWidth=7mm WireThickness=1.9mm Gauge=STANDARDRECT
  Rotor Winding: WindingType=EdgewiseCoil ParallelBranches=1 ConductorsPerPole=72 AxialClearance=0mm LimitedCrossWidth=0mm LimitedCrossHeight=0mm NumberOfStrands=0 WireWrap=0mm InterturnInsulation=0mm WireDiameter=0mm WireWidth=50mm WireThickness=1.7mm Gauge=STANDARDRECT WindingFillet=0mm
setups:
  Setup1: SYNM Generator RatedOutputPower=44000 RatedVoltage=13800V RatedSpeed=187.5rpm OperatingTemperature=75cel LoadType=InfiniteBus RatedPowerFactor=0.9 ExciterEfficiency=100 StartingFieldResistance=0ohm ExcitingCurrent=340.497221A
reports:
  Current Plot 1: ArmaturePhaseCurrent vs Ang on Setup1 : Performance
