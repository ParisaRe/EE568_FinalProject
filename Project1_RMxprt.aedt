# Ansys Electronics Desktop project, version 2021.2
materials:
  Cogent Power - M270-50A, 50Hz: core_loss_curve{50Hz (0, 0) (0.05, 0.01) (0.1, 0.02) (0.15, 0.045) (0.2, 0.07) (0.25, 0.105) (0.3, 0.14) (0.35, 0.185) (0.4, 0.23) (0.45, 0.28) (0.5, 0.33) (0.55, 0.39) (0.6, 0.45) (0.65, 0.515) (0.7, 0.58) (0.75, 0.655) (0.8, 0.73) (0.85, 0.815) (0.9, 0.9) (0.95, 0.985) (1, 1.07) (1.05, 1.17) (1.1, 1.27) (1.15, 1.385) (1.2, 1.5) (1.25, 1.63) (1.3, 1.76) (1.35, 1.945) (1.4, 2.13) (1.45, 2.325) (1.5, 2.52) (1.55, 2.695) (1.6, 2.87) (1.65, 3) (1.7, 3.13) (1.75, 3.25) (1.8, 3.37)} core_loss_curve{100Hz (0, 0) (0.05, 0.02) (0.1, 0.04) (0.15, 0.105) (0.2, 0.17) (0.25, 0.26) (0.3, 0.35) (0.35, 0.465) (0.4, 0.58) (0.45, 0.715) (0.5, 0.85) (0.55, 1.005) (0.6, 1.16) (0.65, 1.335) (0.7, 1.51) (0.75, 1.705) (0.8, 1.9) (0.85, 2.115) (0.9, 2.33) (0.95, 2.57) (1, 2.81) (1.05, 3.085) (1.1, 3.36) (1.15, 3.67) (1.2, 3.98) (1.25, 4.345) (1.3, 4.71) (1.35, 5.165) (1.4, 5.62) (1.45, 6.155) (1.5, 6.69) (1.55, 7.225) (1.6, 7.76) (1.65, 8.295) (1.7, 8.83) (1.75, 9.365) (1.8, 9.9)} core_loss_curve{200Hz (0, 0) (0.05, 0.05) (0.1, 0.1) (0.15, 0.265) (0.2, 0.43) (0.25, 0.67) (0.3, 0.91) (0.35, 1.21) (0.4, 1.51) (0.45, 1.875) (0.5, 2.24) (0.55, 2.665) (0.6, 3.09) (0.65, 3.58) (0.7, 4.07) (0.75, 4.63) (0.8, 5.19) (0.85, 5.83) (0.9, 6.47) (0.95, 7.205) (1, 7.94) (1.05, 8.775) (1.1, 9.61) (1.15, 10.555) (1.2, 11.5) (1.25, 12.55) (1.3, 13.6) (1.35, 14.95) (1.4, 16.3) (1.45, 17.75) (1.5, 19.2) (1.55, 20.65) (1.6, 22.1) (1.65, 23.55) (1.7, 25) (1.75, 26.45) (1.8, 27.9)} core_loss_curve{400Hz (0, 0) (0.05, 0.145) (0.1, 0.29) (0.15, 0.72) (0.2, 1.15) (0.25, 1.815) (0.3, 2.48) (0.35, 3.325) (0.4, 4.17) (0.45, 5.205) (0.5, 6.24) (0.55, 7.495) (0.6, 8.75) (0.65, 10.225) (0.7, 11.7) (0.75, 13.45) (0.8, 15.2) (0.85, 17.25) (0.9, 19.3) (0.95, 21.7) (1, 24.1) (1.05, 26.9) (1.1, 29.7) (1.15, 32.85) (1.2, 36) (1.25, 39.65) (1.3, 43.3) (1.35, 47.6) (1.4, 51.9) (1.45, 56.9) (1.5, 61.9) (1.55, 66.9) (1.6, 71.9) (1.65, 76.9) (1.7, 81.9) (1.75, 86.9) (1.8, 91.9)} core_loss_curve{1000Hz (0, 0) (0.05, 0.7) (0.1, 1.4) (0.15, 3.205) (0.2, 5.01) (0.25, 7.605) (0.3, 10.2) (0.35, 13.7) (0.4, 17.2) (0.45, 21.65) (0.5, 26.1) (0.55, 31.75) (0.6, 37.4) (0.65, 44.4) (0.7, 51.4) (0.75, 60.05) (0.8, 68.7) (0.85, 79.15) (0.9, 89.6) (0.95, 102.3) (1, 115) (1.05, 130) (1.1, 145) (1.15, 160) (1.2, 175) (1.25, 190) (1.3, 205) (1.35, 220) (1.4, 235) (1.45, 250) (1.5, 265) (1.55, 280) (1.6, 295) (1.65, 310) (1.7, 325) (1.75, 340) (1.8, 355)} permeability{HUnit=A_per_meter BUnit=tesla curve (0, 0) (5, 0.00848205) (10, 0.0186535) (20, 0.0452376) (31.5, 0.1) (42, 0.2) (49.4, 0.3) (56.1, 0.4) (63.1, 0.5) (70.7, 0.6) (79.5, 0.7) (90.1, 0.8) (103, 0.9) (121, 1) (145, 1.1) (185, 1.2) (273, 1.3) (557, 1.4) (1520, 1.5) (3560, 1.6) (6730, 1.7) (11400, 1.8) (20000, 1.89285) (40000, 2.0116) (75000, 2.11928) (130000, 2.21351) (236790, 2.3745) (431300, 2.6336) (785590, 3.0869) (1430900, 3.9022)} conductivity=1818180 core_loss_type="Electrical Steel" core_loss_kh=216.205 core_loss_kc=0.595593 core_loss_ke=2.66671 mass_density=7650
  steel_1008: permeability{HUnit=A_per_meter BUnit=tesla curve (0, 0) (159.2, 0.2402) (318.3, 0.8654) (477.5, 1.1106) (636.6, 1.2458) (795.8, 1.331) (1591.5, 1.5) (3183.1, 1.6) (4774.6, 1.683) (6366.2, 1.741) (7957.7, 1.78) (15915.5, 1.905) (31831, 2.025) (47746.5, 2.085) (63662, 2.13) (79577.5, 2.165) (159155, 2.28) (318310, 2.485) (397887, 2.5851)} conductivity=2000000 mass_density=7872
  vacuum: permittivity=1
  Cogent_2DSF0.950: permeability{HUnit=A_per_meter BUnit=tesla curve (0, 0) (5, 0.00805826) (10, 0.0177215) (20, 0.042977) (31.5, 0.095002) (42, 0.190003) (49.4, 0.285003) (56.1, 0.380004) (63.1, 0.475004) (70.7, 0.570004) (79.5, 0.665005) (90.1, 0.760006) (103, 0.855006) (121, 0.950008) (145, 1.04501) (185, 1.14001) (273, 1.23502) (557, 1.33003) (1520, 1.4251) (3560, 1.52022) (6730, 1.61542) (11400, 1.71072) (20000, 1.79946) (40000, 1.91353) (75000, 2.01803) (130000, 2.111) (236790, 2.27065) (431300, 2.52902) (785590, 2.98192) (1430900, 3.797) (7884000, 11.9478)} conductivity=1818180 core_loss_type="Electrical Steel" core_loss_kh=227.584 core_loss_kc=0.62694 core_loss_ke=2.73599 mass_density=7267.5
  Cogent_2DSF0.970: permeability{HUnit=A_per_meter BUnit=tesla curve (0, 0) (159.2, 0.233) (318.3, 0.83945) (477.5, 1.0773) (636.6, 1.20845) (795.8, 1.2911) (1591.5, 1.45506) (3183.1, 1.55212) (4774.6, 1.63269) (6366.2, 1.68901) (7957.7, 1.7269) (15915.5, 1.84845) (31831, 1.96545) (47746.5, 2.02425) (63662, 2.0685) (79577.5, 2.10305) (159155, 2.2176) (318310, 2.42245) (397887, 2.52255) (1193660, 3.52352)} conductivity=2000000 mass_density=7635.84
  copper: permeability=0.999991 conductivity=58000000 mass_density=8933
  Cogent_2DSF0.980: permeability{HUnit=A_per_meter BUnit=tesla curve (0, 0) (5, 0.00831253) (10, 0.0182807) (20, 0.0443334) (31.5, 0.0980008) (42, 0.196001) (49.4, 0.294001) (56.1, 0.392001) (63.1, 0.490002) (70.7, 0.588002) (79.5, 0.686002) (90.1, 0.784002) (103, 0.882003) (121, 0.980003) (145, 1.078) (185, 1.176) (273, 1.27401) (557, 1.37201) (1520, 1.47004) (3560, 1.56809) (6730, 1.66617) (11400, 1.76429) (20000, 1.8555) (40000, 1.97237) (75000, 2.07878) (130000, 2.17251) (236790, 2.33296) (431300, 2.59177) (785590, 3.04491) (1430900, 3.86012) (7884000, 12.0122)} conductivity=1818180 core_loss_type="Electrical Steel" core_loss_kh=220.617 core_loss_kc=0.607748 core_loss_ke=2.69378 mass_density=7497
  Cogent_2DSF0.990: permeability{HUnit=A_per_meter BUnit=tesla curve (0, 0) (5, 0.00839729) (10, 0.0184671) (20, 0.0447855) (31.5, 0.0990004) (42, 0.198001) (49.4, 0.297001) (56.1, 0.396001) (63.1, 0.495001) (70.7, 0.594001) (79.5, 0.693001) (90.1, 0.792001) (103, 0.891001) (121, 0.990002) (145, 1.089) (185, 1.188) (273, 1.287) (557, 1.38601) (1520, 1.48502) (3560, 1.58404) (6730, 1.68308) (11400, 1.78214) (20000, 1.87417) (40000, 1.99199) (75000, 2.09903) (130000, 2.19301) (236790, 2.35373) (431300, 2.61268) (785590, 3.0659) (1430900, 3.88116) (7884000, 12.0337)} conductivity=1818180 core_loss_type="Electrical Steel" core_loss_kh=218.389 core_loss_kc=0.601609 core_loss_ke=2.68014 mass_density=7573.5
  steel_1010: permittivity=1 permeability{HUnit=A_per_meter BUnit=tesla curve (0, 0) (238.7, 0.2003) (318.3, 0.3204) (358.1, 0.40045) (437.7, 0.50055) (477.5, 0.5606) (636.6, 0.7908) (795.8, 0.931) (1114.1, 1.1014) (1273.2, 1.2016) (1591.5, 1.302) (2228.2, 1.4028) (3183.1, 1.524) (4774.6, 1.626) (6366.2, 1.698) (7957.7, 1.73) (15915.5, 1.87) (31831, 1.99) (47746.5, 2.04) (63662, 2.07) (79577.5, 2.095) (159155, 2.2) (318310, 2.4)} conductivity=2000000 lande_g_factor=2 mass_density=7872
  steel_1010_2DSF0.990: permeability{HUnit=A_per_meter BUnit=tesla curve (0, 0) (238.7, 0.1983) (318.3, 0.3172) (358.1, 0.39645) (437.7, 0.49555) (477.5, 0.555) (636.6, 0.7829) (795.8, 0.9217) (1114.1, 1.0904) (1273.2, 1.1896) (1591.5, 1.289) (2228.2, 1.3888) (3183.1, 1.5088) (4774.6, 1.6098) (6366.2, 1.6811) (7957.7, 1.7128) (15915.5, 1.8515) (31831, 1.9705) (47746.5, 2.0202) (63662, 2.0501) (79577.5, 2.07505) (159155, 2.18) (318310, 2.38) (1909860, 4.38)} conductivity=2000000 mass_density=7793.28
  steel_1010_2DSF0.970: permeability{HUnit=A_per_meter BUnit=tesla curve (0, 0) (159.2, 0.233) (318.3, 0.83945) (477.5, 1.0773) (636.6, 1.20845) (795.8, 1.2911) (1591.5, 1.45506) (3183.1, 1.55212) (4774.6, 1.63269) (6366.2, 1.68901) (7957.7, 1.7269) (15915.5, 1.84845) (31831, 1.96545) (47746.5, 2.02425) (63662, 2.0685) (79577.5, 2.10305) (159155, 2.2176) (318310, 2.42245) (397887, 2.52255) (1193660, 3.52352)} conductivity=2000000 mass_density=7635.84

design RMxprtDesign1 (RMxprt, Three Phase Synchronous Machine, model units mm)
variables:
  Di = 5484.975692mm
  Do = 6094.417435mm
  L = 1076.972459mm
  slot_h = 102.077952mm
  slot_w = 22.63265393mm
  d_o = 5454.808326mm
  d_i = 4000mm
  pole_w = (360.2540796-40) mm
  pole_h = 358.4315657mm
  shoe_w = (450.3175995-80) mm
  shoe_h = 98.78203737mm
machine:
  Machine: FrictionLoss=100W WindLoss=100W ReferenceSpeed=187.5rpm NumberOfPoles=32
  Stator: SkewWidth=0 NumberOfSlots=252 LaminationSectors=0 PressBoardThickness=0mm OuterDiameter=Do InnerDiameter=Di Length=L StackingFactor=0.98 SteelType="Cogent Power - M270-50A, 50Hz" SlotType=6
  Rotor: OuterDiameter=d_o InnerDiameter=d_i Length=L SteelType=steel_1010 SecondAirGap=0mm PoleBodyHeight=pole_h PoleShoeHeight=shoe_h Off2x=0mm Off2y=0mm PoleArcOffset=0mm PoleBodyWidth=pole_w PoleShoeWidth=shoe_w PoleStackingFactor=0.97 PoleSteelType=steel_1008 PressBoardThickness=0mm StackingFactor=0.99 ShoeInsulation=0mm PoleInsulation=0mm WindingClearance=0mm
  Shaft:
  Stator Slot: Hs0=1mm Hs1=1mm Hs2=slot_h Bs0=0mm Bs1=slot_w Bs2=slot_w Rs=0mm ToothWidth=0mm
  Stator Winding: WindingType=Whole-Coiled WindingLayers=2 ParallelBranches=1 ConductorsPerSlot=2 CoilPitch=8 EndAdjustment=0mm BaseInnerRadius=0mm TipInnerDiameter=0mm EndClearance=0mm CoilWrap=0mm SlotLiner=0mm WedgeThickness=0mm LayerInsulation=0mm BottomInsulation=0mm LimitedFillFactor=0.75 WdgNumberofPriodicMultipler=1 NumberOfStrands=40 WireWrap=0mm InterturnInsulation=0mm WireDiameter=0mm WireWidth=7mm WireThickness=1.9mm Gauge=STANDARDRECT
  Rotor Winding: WindingType=EdgewiseCoil ParallelBranches=1 ConductorsPerPole=72*2 AxialClearance=0mm LimitedCrossWidth=0mm LimitedCrossHeight=0mm NumberOfStrands=0 WireWrap=0mm InterturnInsulation=0mm WireDiameter=0mm WireWidth=50mm WireThickness=1.7mm Gauge=STANDARDRECT WindingFillet=0mm
setups:
  Setup1: SYNM Generator RatedOutputPower=44000/2 RatedVoltage=13800V RatedSpeed=187.5rpm OperatingTemperature=75cel LoadType=InfiniteBus RatedPowerFactor=0.9 ExciterEfficiency=100 StartingFieldResistance=0ohm
reports:
  Current Plot 1: ArmaturePhaseCurrent vs Ang on Setup1 : Performance
  Power Plot 1: OutputPower vs Ang on Setup1 : Performance

design Maxwell2DDesign1 (Maxwell 2D, Transient, XY geometry, model units mm)
options: ComputeTransientInductance ModelDepth=1076mm
variables:
  fractions = 4
  Di = 5484.975692mm
  Do = 6094.417435mm
  L = 1076.972459mm
  slot_h = 102.077952mm
  slot_w = 22.63265393mm
  d_o = 5454.808326mm
  d_i = 4000mm
  pole_w = 320.2540796mm
  pole_h = 358.4315657mm
  shoe_w = 370.3175995mm
  shoe_h = 98.78203737mm
  delta = -19deg
  conds = 1
  R1 = 0.012288463ohm
  Le1 = 0.00016735776H
geometry:
  Band [vacuum] = user_primitive(RMxprt/Band, DiaGap=(Di + d_o)/2, DiaYoke=d_i, Length=0mm, SegAngle=0deg, Fractions=1, HalfAxial=0, InfoCore=0)
  Shaft [vacuum] = user_primitive(RMxprt/Band, DiaGap=(Di + d_o)/2, DiaYoke=d_i, Length=0mm, SegAngle=0deg, Fractions=1, HalfAxial=0, InfoCore=100)
  OuterRegion [vacuum] = user_primitive(RMxprt/Band, DiaGap=(Di + d_o)/2, DiaYoke=Do, Length=0mm, SegAngle=0deg, Fractions=fractions, HalfAxial=0, InfoCore=100)
  Tool = user_primitive(RMxprt/Band, DiaGap=(Di + d_o)/2, DiaYoke=Do, Length=0mm, SegAngle=0deg, Fractions=fractions, HalfAxial=0, InfoCore=1)
  Stator [Cogent_2DSF0.980] = user_primitive(RMxprt/SlotCore, DiaGap=Di, DiaYoke=Do, Length=0mm, Skew=0deg, Slots=252, SlotType=6, Hs0=1mm, Hs01=0mm, Hs1=1mm, Hs2=slot_h, Bs0=22.63265393mm, Bs1=slot_w, Bs2=slot_w, Rs=0mm, FilletType=0, HalfSlot=0, SegAngle=15deg, LenRegion=0mm, InfoCore=0)
  Coil_0 [copper] = user_primitive(RMxprt/LapCoil, DiaGap=Di, DiaYoke=Do, Length=0mm, Skew=0deg, Slots=252, SlotType=6, Hs0=1mm, Hs1=1mm, Hs2=slot_h, Bs0=22.63265393mm, Bs1=slot_w, Bs2=slot_w, Rs=0mm, FilletType=0, Layers=2, CoilPitch=8, EndExt=0mm, SpanExt=0mm, BendAngle=0deg, SegAngle=10deg, LenRegion=0mm, InfoCoil=2)
  Coil_1..Coil_62 [copper], Coil_63..Coil_251 = Coil_0.duplicate_around_axis(axis=Z, angle=1.4285714deg, total=252)
  Coil_0.unite(Coil_63, Coil_126, Coil_189)
  Coil_1.unite(Coil_64, Coil_127, Coil_190)
  Coil_2.unite(Coil_65, Coil_128, Coil_191)
  Coil_3.unite(Coil_66, Coil_129, Coil_192)
  Coil_4.unite(Coil_67, Coil_130, Coil_193)
  Coil_5.unite(Coil_68, Coil_131, Coil_194)
  Coil_6.unite(Coil_69, Coil_132, Coil_195)
  Coil_7.unite(Coil_70, Coil_133, Coil_196)
  Coil_8.unite(Coil_71, Coil_134, Coil_197)
  Coil_9.unite(Coil_72, Coil_135, Coil_198)
  Coil_10.unite(Coil_73, Coil_136, Coil_199)
  Coil_11.unite(Coil_74, Coil_137, Coil_200)
  Coil_12.unite(Coil_75, Coil_138, Coil_201)
  Coil_13.unite(Coil_76, Coil_139, Coil_202)
  Coil_14.unite(Coil_77, Coil_140, Coil_203)
  Coil_15.unite(Coil_78, Coil_141, Coil_204)
  Coil_16.unite(Coil_79, Coil_142, Coil_205)
  Coil_17.unite(Coil_80, Coil_143, Coil_206)
  Coil_18.unite(Coil_81, Coil_144, Coil_207)
  Coil_19.unite(Coil_82, Coil_145, Coil_208)
  Coil_20.unite(Coil_83, Coil_146, Coil_209)
  Coil_21.unite(Coil_84, Coil_147, Coil_210)
  Coil_22.unite(Coil_85, Coil_148, Coil_211)
  Coil_23.unite(Coil_86, Coil_149, Coil_212)
  Coil_24.unite(Coil_87, Coil_150, Coil_213)
  Coil_25.unite(Coil_88, Coil_151, Coil_214)
  Coil_26.unite(Coil_89, Coil_152, Coil_215)
  Coil_27.unite(Coil_90, Coil_153, Coil_216)
  Coil_28.unite(Coil_91, Coil_154, Coil_217)
  Coil_29.unite(Coil_92, Coil_155, Coil_218)
  Coil_30.unite(Coil_93, Coil_156, Coil_219)
  Coil_31.unite(Coil_94, Coil_157, Coil_220)
  Coil_32.unite(Coil_95, Coil_158, Coil_221)
  Coil_33.unite(Coil_96, Coil_159, Coil_222)
  Coil_34.unite(Coil_97, Coil_160, Coil_223)
  Coil_35.unite(Coil_98, Coil_161, Coil_224)
  Coil_36.unite(Coil_99, Coil_162, Coil_225)
  Coil_37.unite(Coil_100, Coil_163, Coil_226)
  Coil_38.unite(Coil_101, Coil_164, Coil_227)
  Coil_39.unite(Coil_102, Coil_165, Coil_228)
  Coil_40.unite(Coil_103, Coil_166, Coil_229)
  Coil_41.unite(Coil_104, Coil_167, Coil_230)
  Coil_42.unite(Coil_105, Coil_168, Coil_231)
  Coil_43.unite(Coil_106, Coil_169, Coil_232)
  Coil_44.unite(Coil_107, Coil_170, Coil_233)
  Coil_45.unite(Coil_108, Coil_171, Coil_234)
  Coil_46.unite(Coil_109, Coil_172, Coil_235)
  Coil_47.unite(Coil_110, Coil_173, Coil_236)
  Coil_48.unite(Coil_111, Coil_174, Coil_237)
  Coil_49.unite(Coil_112, Coil_175, Coil_238)
  Coil_50.unite(Coil_113, Coil_176, Coil_239)
  Coil_51.unite(Coil_114, Coil_177, Coil_240)
  Coil_52.unite(Coil_115, Coil_178, Coil_241)
  Coil_53.unite(Coil_116, Coil_179, Coil_242)
  Coil_54.unite(Coil_117, Coil_180, Coil_243)
  Coil_55.unite(Coil_118, Coil_181, Coil_244)
  Coil_56.unite(Coil_119, Coil_182, Coil_245)
  Coil_57.unite(Coil_120, Coil_183, Coil_246)
  Coil_58.unite(Coil_121, Coil_184, Coil_247)
  Coil_59.unite(Coil_122, Coil_185, Coil_248)
  Coil_60.unite(Coil_123, Coil_186, Coil_249)
  Coil_61.unite(Coil_124, Coil_187, Coil_250)
  Coil_62.unite(Coil_125, Coil_188, Coil_251)
  CoilRe_0 [copper] = user_primitive(RMxprt/LapCoil, DiaGap=Di, DiaYoke=Do, Length=0mm, Skew=0deg, Slots=252, SlotType=6, Hs0=1mm, Hs1=1mm, Hs2=slot_h, Bs0=22.63265393mm, Bs1=slot_w, Bs2=slot_w, Rs=0mm, FilletType=0, Layers=2, CoilPitch=8, EndExt=0mm, SpanExt=0mm, BendAngle=0deg, SegAngle=10deg, LenRegion=0mm, InfoCoil=3)
  CoilRe_0.rotate(axis=Z, angle=-11.428571deg)
  CoilRe_1..CoilRe_62 [copper], CoilRe_63..CoilRe_251 = CoilRe_0.duplicate_around_axis(axis=Z, angle=1.4285714deg, total=252)
  CoilRe_0.unite(CoilRe_63, CoilRe_126, CoilRe_189)
  CoilRe_1.unite(CoilRe_64, CoilRe_127, CoilRe_190)
  CoilRe_2.unite(CoilRe_65, CoilRe_128, CoilRe_191)
  CoilRe_3.unite(CoilRe_66, CoilRe_129, CoilRe_192)
  CoilRe_4.unite(CoilRe_67, CoilRe_130, CoilRe_193)
  CoilRe_5.unite(CoilRe_68, CoilRe_131, CoilRe_194)
  CoilRe_6.unite(CoilRe_69, CoilRe_132, CoilRe_195)
  CoilRe_7.unite(CoilRe_70, CoilRe_133, CoilRe_196)
  CoilRe_8.unite(CoilRe_71, CoilRe_134, CoilRe_197)
  CoilRe_9.unite(CoilRe_72, CoilRe_135, CoilRe_198)
  CoilRe_10.unite(CoilRe_73, CoilRe_136, CoilRe_199)
  CoilRe_11.unite(CoilRe_74, CoilRe_137, CoilRe_200)
  CoilRe_12.unite(CoilRe_75, CoilRe_138, CoilRe_201)
  CoilRe_13.unite(CoilRe_76, CoilRe_139, CoilRe_202)
  CoilRe_14.unite(CoilRe_77, CoilRe_140, CoilRe_203)
  CoilRe_15.unite(CoilRe_78, CoilRe_141, CoilRe_204)
  CoilRe_16.unite(CoilRe_79, CoilRe_142, CoilRe_205)
  CoilRe_17.unite(CoilRe_80, CoilRe_143, CoilRe_206)
  CoilRe_18.unite(CoilRe_81, CoilRe_144, CoilRe_207)
  CoilRe_19.unite(CoilRe_82, CoilRe_145, CoilRe_208)
  CoilRe_20.unite(CoilRe_83, CoilRe_146, CoilRe_209)
  CoilRe_21.unite(CoilRe_84, CoilRe_147, CoilRe_210)
  CoilRe_22.unite(CoilRe_85, CoilRe_148, CoilRe_211)
  CoilRe_23.unite(CoilRe_86, CoilRe_149, CoilRe_212)
  CoilRe_24.unite(CoilRe_87, CoilRe_150, CoilRe_213)
  CoilRe_25.unite(CoilRe_88, CoilRe_151, CoilRe_214)
  CoilRe_26.unite(CoilRe_89, CoilRe_152, CoilRe_215)
  CoilRe_27.unite(CoilRe_90, CoilRe_153, CoilRe_216)
  CoilRe_28.unite(CoilRe_91, CoilRe_154, CoilRe_217)
  CoilRe_29.unite(CoilRe_92, CoilRe_155, CoilRe_218)
  CoilRe_30.unite(CoilRe_93, CoilRe_156, CoilRe_219)
  CoilRe_31.unite(CoilRe_94, CoilRe_157, CoilRe_220)
  CoilRe_32.unite(CoilRe_95, CoilRe_158, CoilRe_221)
  CoilRe_33.unite(CoilRe_96, CoilRe_159, CoilRe_222)
  CoilRe_34.unite(CoilRe_97, CoilRe_160, CoilRe_223)
  CoilRe_35.unite(CoilRe_98, CoilRe_161, CoilRe_224)
  CoilRe_36.unite(CoilRe_99, CoilRe_162, CoilRe_225)
  CoilRe_37.unite(CoilRe_100, CoilRe_163, CoilRe_226)
  CoilRe_38.unite(CoilRe_101, CoilRe_164, CoilRe_227)
  CoilRe_39.unite(CoilRe_102, CoilRe_165, CoilRe_228)
  CoilRe_40.unite(CoilRe_103, CoilRe_166, CoilRe_229)
  CoilRe_41.unite(CoilRe_104, CoilRe_167, CoilRe_230)
  CoilRe_42.unite(CoilRe_105, CoilRe_168, CoilRe_231)
  CoilRe_43.unite(CoilRe_106, CoilRe_169, CoilRe_232)
  CoilRe_44.unite(CoilRe_107, CoilRe_170, CoilRe_233)
  CoilRe_45.unite(CoilRe_108, CoilRe_171, CoilRe_234)
  CoilRe_46.unite(CoilRe_109, CoilRe_172, CoilRe_235)
  CoilRe_47.unite(CoilRe_110, CoilRe_173, CoilRe_236)
  CoilRe_48.unite(CoilRe_111, CoilRe_174, CoilRe_237)
  CoilRe_49.unite(CoilRe_112, CoilRe_175, CoilRe_238)
  CoilRe_50.unite(CoilRe_113, CoilRe_176, CoilRe_239)
  CoilRe_51.unite(CoilRe_114, CoilRe_177, CoilRe_240)
  CoilRe_52.unite(CoilRe_115, CoilRe_178, CoilRe_241)
  CoilRe_53.unite(CoilRe_116, CoilRe_179, CoilRe_242)
  CoilRe_54.unite(CoilRe_117, CoilRe_180, CoilRe_243)
  CoilRe_55.unite(CoilRe_118, CoilRe_181, CoilRe_244)
  CoilRe_56.unite(CoilRe_119, CoilRe_182, CoilRe_245)
  CoilRe_57.unite(CoilRe_120, CoilRe_183, CoilRe_246)
  CoilRe_58.unite(CoilRe_121, CoilRe_184, CoilRe_247)
  CoilRe_59.unite(CoilRe_122, CoilRe_185, CoilRe_248)
  CoilRe_60.unite(CoilRe_123, CoilRe_186, CoilRe_249)
  CoilRe_61.unite(CoilRe_124, CoilRe_187, CoilRe_250)
  CoilRe_62.unite(CoilRe_125, CoilRe_188, CoilRe_251)
  Rotor [steel_1010_2DSF0.990] = user_primitive(RMxprt/SalientPoleCore, DiaGap=d_o, DiaYoke=d_i, Length=0mm, Skew=0deg, Slots=0, SlotType=0, Hs0=0mm, Hs01=0mm, Hs1=0mm, Hs2=0mm, Bs0=0mm, Bs1=0mm, Bs2=0mm, Rs=0mm, FilletType=0, SlotPitch=0deg, CenterPitch=0deg, Poles=32, PoleType=1, WidthShoe=shoe_w, HeightShoe=shoe_h, WidthBody=pole_w, HeightBody=pole_h, AirGap2=0mm, Offset=0mm, Off2_x=0mm, Off2_y=0mm, Bp1/Rp1=0mm, Bp2/Rp2=0mm, CoilEndExt=0mm, EndRingType=0, BarEndExt=0mm, RingLength=0mm, RingHeight=0mm, SegAngle=15deg, LenRegion=0mm, InfoCore=7)
  Pole [steel_1010_2DSF0.970] = user_primitive(RMxprt/SalientPoleCore, DiaGap=d_o, DiaYoke=d_i, Length=0mm, Skew=0deg, Slots=0, SlotType=0, Hs0=0mm, Hs01=0mm, Hs1=0mm, Hs2=0mm, Bs0=0mm, Bs1=0mm, Bs2=0mm, Rs=0mm, FilletType=0, SlotPitch=0deg, CenterPitch=0deg, Poles=32, PoleType=1, WidthShoe=shoe_w, HeightShoe=shoe_h, WidthBody=pole_w, HeightBody=pole_h, AirGap2=0mm, Offset=0mm, Off2_x=0mm, Off2_y=0mm, Bp1/Rp1=0mm, Bp2/Rp2=0mm, CoilEndExt=0mm, EndRingType=0, BarEndExt=0mm, RingLength=0mm, RingHeight=0mm, SegAngle=15deg, LenRegion=0mm, InfoCore=6)
  Field_0 [copper] = user_primitive(RMxprt/SalientPoleCore, DiaGap=d_o, DiaYoke=d_i, Length=0mm, Skew=0deg, Slots=0, SlotType=0, Hs0=0mm, Hs01=0mm, Hs1=0mm, Hs2=0mm, Bs0=0mm, Bs1=0mm, Bs2=0mm, Rs=0mm, FilletType=0, SlotPitch=0deg, CenterPitch=0deg, Poles=32, PoleType=1, WidthShoe=shoe_w, HeightShoe=shoe_h, WidthBody=pole_w, HeightBody=pole_h, AirGap2=0mm, Offset=0mm, Off2_x=0mm, Off2_y=0mm, Bp1/Rp1=0mm, Bp2/Rp2=0mm, CoilEndExt=0mm, EndRingType=0, BarEndExt=0mm, RingLength=0mm, RingHeight=0mm, SegAngle=15deg, LenRegion=0mm, InfoCore=4)
  Field_1..Field_7 [copper], Field_8..Field_31 = Field_0.duplicate_around_axis(axis=Z, angle=11.25deg, total=32)
  Field_0.unite(Field_8, Field_16, Field_24)
  Field_1.unite(Field_9, Field_17, Field_25)
  Field_2.unite(Field_10, Field_18, Field_26)
  Field_3.unite(Field_11, Field_19, Field_27)
  Field_4.unite(Field_12, Field_20, Field_28)
  Field_5.unite(Field_13, Field_21, Field_29)
  Field_6.unite(Field_14, Field_22, Field_30)
  Field_7.unite(Field_15, Field_23, Field_31)
  FieldRe_0 [copper] = user_primitive(RMxprt/SalientPoleCore, DiaGap=d_o, DiaYoke=d_i, Length=0mm, Skew=0deg, Slots=0, SlotType=0, Hs0=0mm, Hs01=0mm, Hs1=0mm, Hs2=0mm, Bs0=0mm, Bs1=0mm, Bs2=0mm, Rs=0mm, FilletType=0, SlotPitch=0deg, CenterPitch=0deg, Poles=32, PoleType=1, WidthShoe=shoe_w, HeightShoe=shoe_h, WidthBody=pole_w, HeightBody=pole_h, AirGap2=0mm, Offset=0mm, Off2_x=0mm, Off2_y=0mm, Bp1/Rp1=0mm, Bp2/Rp2=0mm, CoilEndExt=0mm, EndRingType=0, BarEndExt=0mm, RingLength=0mm, RingHeight=0mm, SegAngle=15deg, LenRegion=0mm, InfoCore=5)
  FieldRe_1..FieldRe_7 [copper], FieldRe_8..FieldRe_31 = FieldRe_0.duplicate_around_axis(axis=Z, angle=11.25deg, total=32)
  FieldRe_0.unite(FieldRe_8, FieldRe_16, FieldRe_24)
  FieldRe_1.unite(FieldRe_9, FieldRe_17, FieldRe_25)
  FieldRe_2.unite(FieldRe_10, FieldRe_18, FieldRe_26)
  FieldRe_3.unite(FieldRe_11, FieldRe_19, FieldRe_27)
  FieldRe_4.unite(FieldRe_12, FieldRe_20, FieldRe_28)
  FieldRe_5.unite(FieldRe_13, FieldRe_21, FieldRe_29)
  FieldRe_6.unite(FieldRe_14, FieldRe_22, FieldRe_30)
  FieldRe_7.unite(FieldRe_15, FieldRe_23, FieldRe_31)
  InnerRegion [vacuum] = user_primitive(RMxprt/SalientPoleCore, DiaGap=d_o, DiaYoke=d_i, Length=0mm, Skew=0deg, Slots=0, SlotType=0, Hs0=0mm, Hs01=0mm, Hs1=0mm, Hs2=0mm, Bs0=0mm, Bs1=0mm, Bs2=0mm, Rs=0mm, FilletType=0, SlotPitch=0deg, CenterPitch=0deg, Poles=32, PoleType=1, WidthShoe=shoe_w, HeightShoe=shoe_h, WidthBody=pole_w, HeightBody=pole_h, AirGap2=0mm, Offset=0mm, Off2_x=0mm, Off2_y=0mm, Bp1/Rp1=0mm, Bp2/Rp2=0mm, CoilEndExt=0mm, EndRingType=0, BarEndExt=0mm, RingLength=0mm, RingHeight=0mm, SegAngle=15deg, LenRegion=0mm, InfoCore=100)
  Tool_1 = Tool.copy()
  Band.subtract(Tool_1)
  Tool_2 = Tool.copy()
  InnerRegion.subtract(Tool_2)
  Tool_3 = Tool.copy()
  Shaft.subtract(Tool_3)
  Tool_4 = Tool.copy()
  Stator.subtract(Tool_4)
  Tool_5 = Tool.copy()
  Coil_0.subtract(Tool_5)
  Tool_6 = Tool.copy()
  Coil_1.subtract(Tool_6)
  Tool_7 = Tool.copy()
  Coil_2.subtract(Tool_7)
  Tool_8 = Tool.copy()
  Coil_3.subtract(Tool_8)
  Tool_9 = Tool.copy()
  Coil_4.subtract(Tool_9)
  Tool_10 = Tool.copy()
  Coil_5.subtract(Tool_10)
  Tool_11 = Tool.copy()
  Coil_6.subtract(Tool_11)
  Tool_12 = Tool.copy()
  Coil_7.subtract(Tool_12)
  Tool_13 = Tool.copy()
  Coil_8.subtract(Tool_13)
  Tool_14 = Tool.copy()
  Coil_9.subtract(Tool_14)
  Tool_15 = Tool.copy()
  Coil_10.subtract(Tool_15)
  Tool_16 = Tool.copy()
  Coil_11.subtract(Tool_16)
  Tool_17 = Tool.copy()
  Coil_12.subtract(Tool_17)
  Tool_18 = Tool.copy()
  Coil_13.subtract(Tool_18)
  Tool_19 = Tool.copy()
  Coil_14.subtract(Tool_19)
  Tool_20 = Tool.copy()
  Coil_15.subtract(Tool_20)
  Tool_21 = Tool.copy()
  Coil_16.subtract(Tool_21)
  Tool_22 = Tool.copy()
  Coil_17.subtract(Tool_22)
  Tool_23 = Tool.copy()
  Coil_18.subtract(Tool_23)
  Tool_24 = Tool.copy()
  Coil_19.subtract(Tool_24)
  Tool_25 = Tool.copy()
  Coil_20.subtract(Tool_25)
  Tool_26 = Tool.copy()
  Coil_21.subtract(Tool_26)
  Tool_27 = Tool.copy()
  Coil_22.subtract(Tool_27)
  Tool_28 = Tool.copy()
  Coil_23.subtract(Tool_28)
  Tool_29 = Tool.copy()
  Coil_24.subtract(Tool_29)
  Tool_30 = Tool.copy()
  Coil_25.subtract(Tool_30)
  Tool_31 = Tool.copy()
  Coil_26.subtract(Tool_31)
  Tool_32 = Tool.copy()
  Coil_27.subtract(Tool_32)
  Tool_33 = Tool.copy()
  Coil_28.subtract(Tool_33)
  Tool_34 = Tool.copy()
  Coil_29.subtract(Tool_34)
  Tool_35 = Tool.copy()
  Coil_30.subtract(Tool_35)
  Tool_36 = Tool.copy()
  Coil_31.subtract(Tool_36)
  Tool_37 = Tool.copy()
  Coil_32.subtract(Tool_37)
  Tool_38 = Tool.copy()
  Coil_33.subtract(Tool_38)
  Tool_39 = Tool.copy()
  Coil_34.subtract(Tool_39)
  Tool_40 = Tool.copy()
  Coil_35.subtract(Tool_40)
  Tool_41 = Tool.copy()
  Coil_36.subtract(Tool_41)
  Tool_42 = Tool.copy()
  Coil_37.subtract(Tool_42)
  Tool_43 = Tool.copy()
  Coil_38.subtract(Tool_43)
  Tool_44 = Tool.copy()
  Coil_39.subtract(Tool_44)
  Tool_45 = Tool.copy()
  Coil_40.subtract(Tool_45)
  Tool_46 = Tool.copy()
  Coil_41.subtract(Tool_46)
  Tool_47 = Tool.copy()
  Coil_42.subtract(Tool_47)
  Tool_48 = Tool.copy()
  Coil_43.subtract(Tool_48)
  Tool_49 = Tool.copy()
  Coil_44.subtract(Tool_49)
  Tool_50 = Tool.copy()
  Coil_45.subtract(Tool_50)
  Tool_51 = Tool.copy()
  Coil_46.subtract(Tool_51)
  Tool_52 = Tool.copy()
  Coil_47.subtract(Tool_52)
  Tool_53 = Tool.copy()
  Coil_48.subtract(Tool_53)
  Tool_54 = Tool.copy()
  Coil_49.subtract(Tool_54)
  Tool_55 = Tool.copy()
  Coil_50.subtract(Tool_55)
  Tool_56 = Tool.copy()
  Coil_51.subtract(Tool_56)
  Tool_57 = Tool.copy()
  Coil_52.subtract(Tool_57)
  Tool_58 = Tool.copy()
  Coil_53.subtract(Tool_58)
  Tool_59 = Tool.copy()
  Coil_54.subtract(Tool_59)
  Tool_60 = Tool.copy()
  Coil_55.subtract(Tool_60)
  Tool_61 = Tool.copy()
  Coil_56.subtract(Tool_61)
  Tool_62 = Tool.copy()
  Coil_57.subtract(Tool_62)
  Tool_63 = Tool.copy()
  Coil_58.subtract(Tool_63)
  Tool_64 = Tool.copy()
  Coil_59.subtract(Tool_64)
  Tool_65 = Tool.copy()
  Coil_60.subtract(Tool_65)
  Tool_66 = Tool.copy()
  Coil_61.subtract(Tool_66)
  Tool_67 = Tool.copy()
  Coil_62.subtract(Tool_67)
  Tool_68 = Tool.copy()
  CoilRe_0.subtract(Tool_68)
  Tool_69 = Tool.copy()
  CoilRe_1.subtract(Tool_69)
  Tool_70 = Tool.copy()
  CoilRe_2.subtract(Tool_70)
  Tool_71 = Tool.copy()
  CoilRe_3.subtract(Tool_71)
  Tool_72 = Tool.copy()
  CoilRe_4.subtract(Tool_72)
  Tool_73 = Tool.copy()
  CoilRe_5.subtract(Tool_73)
  Tool_74 = Tool.copy()
  CoilRe_6.subtract(Tool_74)
  Tool_75 = Tool.copy()
  CoilRe_7.subtract(Tool_75)
  Tool_76 = Tool.copy()
  CoilRe_8.subtract(Tool_76)
  Tool_77 = Tool.copy()
  CoilRe_9.subtract(Tool_77)
  Tool_78 = Tool.copy()
  CoilRe_10.subtract(Tool_78)
  Tool_79 = Tool.copy()
  CoilRe_11.subtract(Tool_79)
  Tool_80 = Tool.copy()
  CoilRe_12.subtract(Tool_80)
  Tool_81 = Tool.copy()
  CoilRe_13.subtract(Tool_81)
  Tool_82 = Tool.copy()
  CoilRe_14.subtract(Tool_82)
  Tool_83 = Tool.copy()
  CoilRe_15.subtract(Tool_83)
  Tool_84 = Tool.copy()
  CoilRe_16.subtract(Tool_84)
  Tool_85 = Tool.copy()
  CoilRe_17.subtract(Tool_85)
  Tool_86 = Tool.copy()
  CoilRe_18.subtract(Tool_86)
  Tool_87 = Tool.copy()
  CoilRe_19.subtract(Tool_87)
  Tool_88 = Tool.copy()
  CoilRe_20.subtract(Tool_88)
  Tool_89 = Tool.copy()
  CoilRe_21.subtract(Tool_89)
  Tool_90 = Tool.copy()
  CoilRe_22.subtract(Tool_90)
  Tool_91 = Tool.copy()
  CoilRe_23.subtract(Tool_91)
  Tool_92 = Tool.copy()
  CoilRe_24.subtract(Tool_92)
  Tool_93 = Tool.copy()
  CoilRe_25.subtract(Tool_93)
  Tool_94 = Tool.copy()
  CoilRe_26.subtract(Tool_94)
  Tool_95 = Tool.copy()
  CoilRe_27.subtract(Tool_95)
  Tool_96 = Tool.copy()
  CoilRe_28.subtract(Tool_96)
  Tool_97 = Tool.copy()
  CoilRe_29.subtract(Tool_97)
  Tool_98 = Tool.copy()
  CoilRe_30.subtract(Tool_98)
  Tool_99 = Tool.copy()
  CoilRe_31.subtract(Tool_99)
  Tool_100 = Tool.copy()
  CoilRe_32.subtract(Tool_100)
  Tool_101 = Tool.copy()
  CoilRe_33.subtract(Tool_101)
  Tool_102 = Tool.copy()
  CoilRe_34.subtract(Tool_102)
  Tool_103 = Tool.copy()
  CoilRe_35.subtract(Tool_103)
  Tool_104 = Tool.copy()
  CoilRe_36.subtract(Tool_104)
  Tool_105 = Tool.copy()
  CoilRe_37.subtract(Tool_105)
  Tool_106 = Tool.copy()
  CoilRe_38.subtract(Tool_106)
  Tool_107 = Tool.copy()
  CoilRe_39.subtract(Tool_107)
  Tool_108 = Tool.copy()
  CoilRe_40.subtract(Tool_108)
  Tool_109 = Tool.copy()
  CoilRe_41.subtract(Tool_109)
  Tool_110 = Tool.copy()
  CoilRe_42.subtract(Tool_110)
  Tool_111 = Tool.copy()
  CoilRe_43.subtract(Tool_111)
  Tool_112 = Tool.copy()
  CoilRe_44.subtract(Tool_112)
  Tool_113 = Tool.copy()
  CoilRe_45.subtract(Tool_113)
  Tool_114 = Tool.copy()
  CoilRe_46.subtract(Tool_114)
  Tool_115 = Tool.copy()
  CoilRe_47.subtract(Tool_115)
  Tool_116 = Tool.copy()
  CoilRe_48.subtract(Tool_116)
  Tool_117 = Tool.copy()
  CoilRe_49.subtract(Tool_117)
  Tool_118 = Tool.copy()
  CoilRe_50.subtract(Tool_118)
  Tool_119 = Tool.copy()
  CoilRe_51.subtract(Tool_119)
  Tool_120 = Tool.copy()
  CoilRe_52.subtract(Tool_120)
  Tool_121 = Tool.copy()
  CoilRe_53.subtract(Tool_121)
  Tool_122 = Tool.copy()
  CoilRe_54.subtract(Tool_122)
  Tool_123 = Tool.copy()
  CoilRe_55.subtract(Tool_123)
  Tool_124 = Tool.copy()
  CoilRe_56.subtract(Tool_124)
  Tool_125 = Tool.copy()
  CoilRe_57.subtract(Tool_125)
  Tool_126 = Tool.copy()
  CoilRe_58.subtract(Tool_126)
  Tool_127 = Tool.copy()
  CoilRe_59.subtract(Tool_127)
  Tool_128 = Tool.copy()
  CoilRe_60.subtract(Tool_128)
  Tool_129 = Tool.copy()
  CoilRe_61.subtract(Tool_129)
  Tool_130 = Tool.copy()
  CoilRe_62.subtract(Tool_130)
  Tool_131 = Tool.copy()
  Rotor.subtract(Tool_131)
  Tool_132 = Tool.copy()
  Pole.subtract(Tool_132)
  Tool_133 = Tool.copy()
  Field_0.subtract(Tool_133)
  Tool_134 = Tool.copy()
  Field_1.subtract(Tool_134)
  Tool_135 = Tool.copy()
  Field_2.subtract(Tool_135)
  Tool_136 = Tool.copy()
  Field_3.subtract(Tool_136)
  Tool_137 = Tool.copy()
  Field_4.subtract(Tool_137)
  Tool_138 = Tool.copy()
  Field_5.subtract(Tool_138)
  Tool_139 = Tool.copy()
  Field_6.subtract(Tool_139)
  Tool_140 = Tool.copy()
  Field_7.subtract(Tool_140)
  Tool_141 = Tool.copy()
  FieldRe_0.subtract(Tool_141)
  Tool_142 = Tool.copy()
  FieldRe_1.subtract(Tool_142)
  Tool_143 = Tool.copy()
  FieldRe_2.subtract(Tool_143)
  Tool_144 = Tool.copy()
  FieldRe_3.subtract(Tool_144)
  Tool_145 = Tool.copy()
  FieldRe_4.subtract(Tool_145)
  Tool_146 = Tool.copy()
  FieldRe_5.subtract(Tool_146)
  Tool_147 = Tool.copy()
  FieldRe_6.subtract(Tool_147)
  FieldRe_7.subtract(Tool)
motion:
  MotionSetup1: Band Move_Type=Rotate Coordinate_System=Global Axis=Z Is_Positive=true InitPos=13.8393deg Angular_Velocity=187.5rpm Objects=Band
  Moving1: Moving Objects=[Shaft, Rotor, Pole, Field_0..Field_7, FieldRe_0..FieldRe_7, InnerRegion]
boundaries and excitations:
  VectorPotential1: Vector Potential Edges=OuterRegion.edge(at (2154.7, 2154.7, 0)) Value=0
  Independent1: Independent Edges=OuterRegion.edge(at (1523.6, 0, 0))
  Dependent1: Dependent Edges=OuterRegion.edge(at (0, 1523.6, 0)) ReverseU Independent=Independent1 SameAsMaster=true
  PhA_0: Coil Objects=Coil_0 Conductor_number=conds Winding=PhaseA PolarityType=Positive
  PhARe_0: Coil Objects=CoilRe_8 Conductor_number=conds Winding=PhaseA PolarityType=Negative
  PhA_1: Coil Objects=Coil_1 Conductor_number=conds Winding=PhaseA PolarityType=Positive
  PhARe_1: Coil Objects=CoilRe_9 Conductor_number=conds Winding=PhaseA PolarityType=Negative
  PhA_2: Coil Objects=Coil_2 Conductor_number=conds Winding=PhaseA PolarityType=Positive
  PhARe_2: Coil Objects=CoilRe_10 Conductor_number=conds Winding=PhaseA PolarityType=Negative
  PhCRe_3: Coil Objects=Coil_3 Conductor_number=conds Winding=PhaseC PolarityType=Negative
  PhC_3: Coil Objects=CoilRe_11 Conductor_number=conds Winding=PhaseC PolarityType=Positive
  PhCRe_4: Coil Objects=Coil_4 Conductor_number=conds Winding=PhaseC PolarityType=Negative
  PhC_4: Coil Objects=CoilRe_12 Conductor_number=conds Winding=PhaseC PolarityType=Positive
  PhCRe_5: Coil Objects=Coil_5 Conductor_number=conds Winding=PhaseC PolarityType=Negative
  PhC_5: Coil Objects=CoilRe_13 Conductor_number=conds Winding=PhaseC PolarityType=Positive
  PhB_6: Coil Objects=Coil_6 Conductor_number=conds Winding=PhaseB PolarityType=Positive
  PhBRe_6: Coil Objects=CoilRe_14 Conductor_number=conds Winding=PhaseB PolarityType=Negative
  PhB_7: Coil Objects=Coil_7 Conductor_number=conds Winding=PhaseB PolarityType=Positive
  PhBRe_7: Coil Objects=CoilRe_15 Conductor_number=conds Winding=PhaseB PolarityType=Negative
  PhARe_8: Coil Objects=Coil_8 Conductor_number=conds Winding=PhaseA PolarityType=Negative
  PhA_8: Coil Objects=CoilRe_16 Conductor_number=conds Winding=PhaseA PolarityType=Positive
  PhARe_9: Coil Objects=Coil_9 Conductor_number=conds Winding=PhaseA PolarityType=Negative
  PhA_9: Coil Objects=CoilRe_17 Conductor_number=conds Winding=PhaseA PolarityType=Positive
  PhARe_10: Coil Objects=Coil_10 Conductor_number=conds Winding=PhaseA PolarityType=Negative
  PhA_10: Coil Objects=CoilRe_18 Conductor_number=conds Winding=PhaseA PolarityType=Positive
  PhC_11: Coil Objects=Coil_11 Conductor_number=conds Winding=PhaseC PolarityType=Positive
  PhCRe_11: Coil Objects=CoilRe_19 Conductor_number=conds Winding=PhaseC PolarityType=Negative
  PhC_12: Coil Objects=Coil_12 Conductor_number=conds Winding=PhaseC PolarityType=Positive
  PhCRe_12: Coil Objects=CoilRe_20 Conductor_number=conds Winding=PhaseC PolarityType=Negative
  PhC_13: Coil Objects=Coil_13 Conductor_number=conds Winding=PhaseC PolarityType=Positive
  PhCRe_13: Coil Objects=CoilRe_21 Conductor_number=conds Winding=PhaseC PolarityType=Negative
  PhBRe_14: Coil Objects=Coil_14 Conductor_number=conds Winding=PhaseB PolarityType=Negative
  PhB_14: Coil Objects=CoilRe_22 Conductor_number=conds Winding=PhaseB PolarityType=Positive
  PhBRe_15: Coil Objects=Coil_15 Conductor_number=conds Winding=PhaseB PolarityType=Negative
  PhB_15: Coil Objects=CoilRe_23 Conductor_number=conds Winding=PhaseB PolarityType=Positive
  PhA_16: Coil Objects=Coil_16 Conductor_number=conds Winding=PhaseA PolarityType=Positive
  PhARe_16: Coil Objects=CoilRe_24 Conductor_number=conds Winding=PhaseA PolarityType=Negative
  PhA_17: Coil Objects=Coil_17 Conductor_number=conds Winding=PhaseA PolarityType=Positive
  PhARe_17: Coil Objects=CoilRe_25 Conductor_number=conds Winding=PhaseA PolarityType=Negative
  PhA_18: Coil Objects=Coil_18 Conductor_number=conds Winding=PhaseA PolarityType=Positive
  PhARe_18: Coil Objects=CoilRe_26 Conductor_number=conds Winding=PhaseA PolarityType=Negative
  PhCRe_19: Coil Objects=Coil_19 Conductor_number=conds Winding=PhaseC PolarityType=Negative
  PhC_19: Coil Objects=CoilRe_27 Conductor_number=conds Winding=PhaseC PolarityType=Positive
  PhCRe_20: Coil Objects=Coil_20 Conductor_number=conds Winding=PhaseC PolarityType=Negative
  PhC_20: Coil Objects=CoilRe_28 Conductor_number=conds Winding=PhaseC PolarityType=Positive
  PhB_21: Coil Objects=Coil_21 Conductor_number=conds Winding=PhaseB PolarityType=Positive
  PhBRe_21: Coil Objects=CoilRe_29 Conductor_number=conds Winding=PhaseB PolarityType=Negative
  PhB_22: Coil Objects=Coil_22 Conductor_number=conds Winding=PhaseB PolarityType=Positive
  PhBRe_22: Coil Objects=CoilRe_30 Conductor_number=conds Winding=PhaseB PolarityType=Negative
  PhB_23: Coil Objects=Coil_23 Conductor_number=conds Winding=PhaseB PolarityType=Positive
  PhBRe_23: Coil Objects=CoilRe_31 Conductor_number=conds Winding=PhaseB PolarityType=Negative
  PhARe_24: Coil Objects=Coil_24 Conductor_number=conds Winding=PhaseA PolarityType=Negative
  PhA_24: Coil Objects=CoilRe_32 Conductor_number=conds Winding=PhaseA PolarityType=Positive
  PhARe_25: Coil Objects=Coil_25 Conductor_number=conds Winding=PhaseA PolarityType=Negative
  PhA_25: Coil Objects=CoilRe_33 Conductor_number=conds Winding=PhaseA PolarityType=Positive
  PhARe_26: Coil Objects=Coil_26 Conductor_number=conds Winding=PhaseA PolarityType=Negative
  PhA_26: Coil Objects=CoilRe_34 Conductor_number=conds Winding=PhaseA PolarityType=Positive
  PhC_27: Coil Objects=Coil_27 Conductor_number=conds Winding=PhaseC PolarityType=Positive
  PhCRe_27: Coil Objects=CoilRe_35 Conductor_number=conds Winding=PhaseC PolarityType=Negative
  PhC_28: Coil Objects=Coil_28 Conductor_number=conds Winding=PhaseC PolarityType=Positive
  PhCRe_28: Coil Objects=CoilRe_36 Conductor_number=conds Winding=PhaseC PolarityType=Negative
  PhBRe_29: Coil Objects=Coil_29 Conductor_number=conds Winding=PhaseB PolarityType=Negative
  PhB_29: Coil Objects=CoilRe_37 Conductor_number=conds Winding=PhaseB PolarityType=Positive
  PhBRe_30: Coil Objects=Coil_30 Conductor_number=conds Winding=PhaseB PolarityType=Negative
  PhB_30: Coil Objects=CoilRe_38 Conductor_number=conds Winding=PhaseB PolarityType=Positive
  PhBRe_31: Coil Objects=Coil_31 Conductor_number=conds Winding=PhaseB PolarityType=Negative
  PhB_31: Coil Objects=CoilRe_39 Conductor_number=conds Winding=PhaseB PolarityType=Positive
  PhA_32: Coil Objects=Coil_32 Conductor_number=conds Winding=PhaseA PolarityType=Positive
  PhARe_32: Coil Objects=CoilRe_40 Conductor_number=conds Winding=PhaseA PolarityType=Negative
  PhA_33: Coil Objects=Coil_33 Conductor_number=conds Winding=PhaseA PolarityType=Positive
  PhARe_33: Coil Objects=CoilRe_41 Conductor_number=conds Winding=PhaseA PolarityType=Negative
  PhA_34: Coil Objects=Coil_34 Conductor_number=conds Winding=PhaseA PolarityType=Positive
  PhARe_34: Coil Objects=CoilRe_42 Conductor_number=conds Winding=PhaseA PolarityType=Negative
  PhCRe_35: Coil Objects=Coil_35 Conductor_number=conds Winding=PhaseC PolarityType=Negative
  PhC_35: Coil Objects=CoilRe_43 Conductor_number=conds Winding=PhaseC PolarityType=Positive
  PhCRe_36: Coil Objects=Coil_36 Conductor_number=conds Winding=PhaseC PolarityType=Negative
  PhC_36: Coil Objects=CoilRe_44 Conductor_number=conds Winding=PhaseC PolarityType=Positive
  PhB_37: Coil Objects=Coil_37 Conductor_number=conds Winding=PhaseB PolarityType=Positive
  PhBRe_37: Coil Objects=CoilRe_45 Conductor_number=conds Winding=PhaseB PolarityType=Negative
  PhB_38: Coil Objects=Coil_38 Conductor_number=conds Winding=PhaseB PolarityType=Positive
  PhBRe_38: Coil Objects=CoilRe_46 Conductor_number=conds Winding=PhaseB PolarityType=Negative
  PhB_39: Coil Objects=Coil_39 Conductor_number=conds Winding=PhaseB PolarityType=Positive
  PhBRe_39: Coil Objects=CoilRe_47 Conductor_number=conds Winding=PhaseB PolarityType=Negative
  PhARe_40: Coil Objects=Coil_40 Conductor_number=conds Winding=PhaseA PolarityType=Negative
  PhA_40: Coil Objects=CoilRe_48 Conductor_number=conds Winding=PhaseA PolarityType=Positive
  PhARe_41: Coil Objects=Coil_41 Conductor_number=conds Winding=PhaseA PolarityType=Negative
  PhA_41: Coil Objects=CoilRe_49 Conductor_number=conds Winding=PhaseA PolarityType=Positive
  PhC_42: Coil Objects=Coil_42 Conductor_number=conds Winding=PhaseC PolarityType=Positive
  PhCRe_42: Coil Objects=CoilRe_50 Conductor_number=conds Winding=PhaseC PolarityType=Negative
  PhC_43: Coil Objects=Coil_43 Conductor_number=conds Winding=PhaseC PolarityType=Positive
  PhCRe_43: Coil Objects=CoilRe_51 Conductor_number=conds Winding=PhaseC PolarityType=Negative
  PhC_44: Coil Objects=Coil_44 Conductor_number=conds Winding=PhaseC PolarityType=Positive
  PhCRe_44: Coil Objects=CoilRe_52 Conductor_number=conds Winding=PhaseC PolarityType=Negative
  PhBRe_45: Coil Objects=Coil_45 Conductor_number=conds Winding=PhaseB PolarityType=Negative
  PhB_45: Coil Objects=CoilRe_53 Conductor_number=conds Winding=PhaseB PolarityType=Positive
  PhBRe_46: Coil Objects=Coil_46 Conductor_number=conds Winding=PhaseB PolarityType=Negative
  PhB_46: Coil Objects=CoilRe_54 Conductor_number=conds Winding=PhaseB PolarityType=Positive
  PhBRe_47: Coil Objects=Coil_47 Conductor_number=conds Winding=PhaseB PolarityType=Negative
  PhB_47: Coil Objects=CoilRe_55 Conductor_number=conds Winding=PhaseB PolarityType=Positive
  PhA_48: Coil Objects=Coil_48 Conductor_number=conds Winding=PhaseA PolarityType=Positive
  PhARe_48: Coil Objects=CoilRe_56 Conductor_number=conds Winding=PhaseA PolarityType=Negative
  PhA_49: Coil Objects=Coil_49 Conductor_number=conds Winding=PhaseA PolarityType=Positive
  PhARe_49: Coil Objects=CoilRe_57 Conductor_number=conds Winding=PhaseA PolarityType=Negative
  PhCRe_50: Coil Objects=Coil_50 Conductor_number=conds Winding=PhaseC PolarityType=Negative
  PhC_50: Coil Objects=CoilRe_58 Conductor_number=conds Winding=PhaseC PolarityType=Positive
  PhCRe_51: Coil Objects=Coil_51 Conductor_number=conds Winding=PhaseC PolarityType=Negative
  PhC_51: Coil Objects=CoilRe_59 Conductor_number=conds Winding=PhaseC PolarityType=Positive
  PhCRe_52: Coil Objects=Coil_52 Conductor_number=conds Winding=PhaseC PolarityType=Negative
  PhC_52: Coil Objects=CoilRe_60 Conductor_number=conds Winding=PhaseC PolarityType=Positive
  PhB_53: Coil Objects=Coil_53 Conductor_number=conds Winding=PhaseB PolarityType=Positive
  PhBRe_53: Coil Objects=CoilRe_61 Conductor_number=conds Winding=PhaseB PolarityType=Negative
  PhB_54: Coil Objects=Coil_54 Conductor_number=conds Winding=PhaseB PolarityType=Positive
  PhBRe_54: Coil Objects=CoilRe_62 Conductor_number=conds Winding=PhaseB PolarityType=Negative
  PhB_55: Coil Objects=Coil_55 Conductor_number=conds Winding=PhaseB PolarityType=Positive
  PhARe_56: Coil Objects=Coil_56 Conductor_number=conds Winding=PhaseA PolarityType=Negative
  PhARe_57: Coil Objects=Coil_57 Conductor_number=conds Winding=PhaseA PolarityType=Negative
  PhC_58: Coil Objects=Coil_58 Conductor_number=conds Winding=PhaseC PolarityType=Positive
  PhC_59: Coil Objects=Coil_59 Conductor_number=conds Winding=PhaseC PolarityType=Positive
  PhC_60: Coil Objects=Coil_60 Conductor_number=conds Winding=PhaseC PolarityType=Positive
  PhBRe_61: Coil Objects=Coil_61 Conductor_number=conds Winding=PhaseB PolarityType=Negative
  PhBRe_62: Coil Objects=Coil_62 Conductor_number=conds Winding=PhaseB PolarityType=Negative
  PhBRe_244: Coil Objects=CoilRe_0 Conductor_number=conds Winding=PhaseB PolarityType=Negative
  PhA_245: Coil Objects=CoilRe_1 Conductor_number=conds Winding=PhaseA PolarityType=Positive
  PhA_246: Coil Objects=CoilRe_2 Conductor_number=conds Winding=PhaseA PolarityType=Positive
  PhCRe_247: Coil Objects=CoilRe_3 Conductor_number=conds Winding=PhaseC PolarityType=Negative
  PhCRe_248: Coil Objects=CoilRe_4 Conductor_number=conds Winding=PhaseC PolarityType=Negative
  PhCRe_249: Coil Objects=CoilRe_5 Conductor_number=conds Winding=PhaseC PolarityType=Negative
  PhB_250: Coil Objects=CoilRe_6 Conductor_number=conds Winding=PhaseB PolarityType=Positive
  PhB_251: Coil Objects=CoilRe_7 Conductor_number=conds Winding=PhaseB PolarityType=Positive
  Field_0: Coil Objects=Field_0 Conductor_number=72 Winding=Field PolarityType=Positive
  FieldRe_0: Coil Objects=FieldRe_0 Conductor_number=72 Winding=Field PolarityType=Negative
  FieldRe_1: Coil Objects=Field_1 Conductor_number=72 Winding=Field PolarityType=Negative
  Field_1: Coil Objects=FieldRe_1 Conductor_number=72 Winding=Field PolarityType=Positive
  Field_2: Coil Objects=Field_2 Conductor_number=72 Winding=Field PolarityType=Positive
  FieldRe_2: Coil Objects=FieldRe_2 Conductor_number=72 Winding=Field PolarityType=Negative
  FieldRe_3: Coil Objects=Field_3 Conductor_number=72 Winding=Field PolarityType=Negative
  Field_3: Coil Objects=FieldRe_3 Conductor_number=72 Winding=Field PolarityType=Positive
  Field_4: Coil Objects=Field_4 Conductor_number=72 Winding=Field PolarityType=Positive
  FieldRe_4: Coil Objects=FieldRe_4 Conductor_number=72 Winding=Field PolarityType=Negative
  FieldRe_5: Coil Objects=Field_5 Conductor_number=72 Winding=Field PolarityType=Negative
  Field_5: Coil Objects=FieldRe_5 Conductor_number=72 Winding=Field PolarityType=Positive
  Field_6: Coil Objects=Field_6 Conductor_number=72 Winding=Field PolarityType=Positive
  FieldRe_6: Coil Objects=FieldRe_6 Conductor_number=72 Winding=Field PolarityType=Negative
  FieldRe_7: Coil Objects=Field_7 Conductor_number=72 Winding=Field PolarityType=Negative
  Field_7: Coil Objects=FieldRe_7 Conductor_number=72 Winding=Field PolarityType=Positive
  PhaseA: Winding Group Type=Voltage IsSolid=false Current=0A Resistance=R1 Inductance=Le1 Voltage=11267.7*sin(2*pi*50*time+delta) ParallelBranchesNum=1
  PhaseB: Winding Group Type=Voltage IsSolid=false Current=0A Resistance=R1 Inductance=Le1 Voltage=11267.7*sin(2*pi*50*time+delta-2*pi/3) ParallelBranchesNum=1
  PhaseC: Winding Group Type=Voltage IsSolid=false Current=0A Resistance=R1 Inductance=Le1 Voltage=11267.7*sin(2*pi*50*time+delta-4*pi/3) ParallelBranchesNum=1
  Field: Winding Group Type=Current IsSolid=false Current=362.422A ParallelBranchesNum=1
  Y connection: PhaseA, PhaseB, PhaseC
mesh:
  SurfApprox_Main: SurfApproxBased Objects=[Stator, Rotor, Band, OuterRegion, InnerRegion, Shaft] CurvedSurfaceApproxChoice=ManualSettings SurfDev=3.04721mm NormalDev=15deg
  initial mesh: MeshMethod=AnsoftTAU
setups:
  Setup1: Transient NonlinearSolverResidual=0.0001 StopTime=0.05s TimeStep=0.0012s FastReachSteadyState AutoDetectSteadyState FrequencyOfAddedVoltageSource=50Hz StopCriterion=0.005 SaveFieldsType="Every N Steps" N_Steps=1 Steps_From=0s Steps_To=0.05s NumberSolveSteps=1 RangeStart=0s RangeEnd=0.1s InitialTimeStep=0.002s MinTimeStep=0.001s MaxTimeStep=0.003s TimeStepErrTolerance=0.0001
output variables:
  pos = (Moving1.Position -13.8393 * PI/180) * 16 + PI
  cos0 = cos(pos)
  cos1 = cos(pos-2*PI/3)
  cos2 = cos(pos-4*PI/3)
  sin0 = sin(pos)
  sin1 = sin(pos-2*PI/3)
  sin2 = sin(pos-4*PI/3)
  Lad = L(PhaseA,PhaseA)*cos0 + L(PhaseA,PhaseB)*cos1 + L(PhaseA,PhaseC)*cos2
  Laq = L(PhaseA,PhaseA)*sin0 + L(PhaseA,PhaseB)*sin1 + L(PhaseA,PhaseC)*sin2
  Lbd = L(PhaseB,PhaseA)*cos0 + L(PhaseB,PhaseB)*cos1 + L(PhaseB,PhaseC)*cos2
  Lbq = L(PhaseB,PhaseA)*sin0 + L(PhaseB,PhaseB)*sin1 + L(PhaseB,PhaseC)*sin2
  Lcd = L(PhaseC,PhaseA)*cos0 + L(PhaseC,PhaseB)*cos1 + L(PhaseC,PhaseC)*cos2
  Lcq = L(PhaseC,PhaseA)*sin0 + L(PhaseC,PhaseB)*sin1 + L(PhaseC,PhaseC)*sin2
  L_d = (Lad*cos0 + Lbd*cos1 + Lcd*cos2) * 2/3
  L_q = (Laq*sin0 + Lbq*sin1 + Lcq*sin2) * 2/3
  Flux_d = (FluxLinkage(PhaseA)*cos0+FluxLinkage(PhaseB)*cos1+FluxLinkage(PhaseC)*cos2)*2/3
  Flux_q = (FluxLinkage(PhaseA)*sin0+FluxLinkage(PhaseB)*sin1+FluxLinkage(PhaseC)*sin2)*2/3
  I_d = (Current(PhaseA)*cos0 + Current(PhaseB)*cos1 + Current(PhaseC)*cos2)*2/3
  I_q = (Current(PhaseA)*sin0 + Current(PhaseB)*sin1 + Current(PhaseC)*sin2)*2/3
  Irms = sqrt(I_d^2+I_q^2)/sqrt(2)
  Pcu = 3*Irms^2*0
reports:
  Torque: Moving1.Torque vs Time on Setup1 : Transient
  Currents: Current(PhaseA), Current(PhaseB), Current(PhaseC) vs Time on Setup1 : Transient
  Induced Voltages: InducedVoltage(PhaseA), InducedVoltage(PhaseB), InducedVoltage(PhaseC) vs Time on Setup1 : Transient
  Flux Linkages: FluxLinkage(PhaseA), FluxLinkage(PhaseB), FluxLinkage(PhaseC) vs Time on Setup1 : Transient
  Voltages: InputVoltage(PhaseA), InputVoltage(PhaseB), InputVoltage(PhaseC) vs Time on Setup1 : Transient
  Powers: InputVoltage(PhaseA)*Current(PhaseA) + InputVoltage(PhaseB)*Current(PhaseB) + InputVoltage(PhaseC)*Current(PhaseC), Moving1.Speed*Moving1.Torque vs Time on Setup1 : Transient
  L_dq: L_d, L_q vs Time on Setup1 : Transient
  Flux_dq: Flux_d, Flux_q vs Time on Setup1 : Transient
  I_dq: I_d, I_q vs Time on Setup1 : Transient
  Loss Plot 1: CoreLoss vs Time on Setup1 : Transient
